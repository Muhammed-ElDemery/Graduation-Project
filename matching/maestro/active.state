ADE simulation setup
Test GP:matching:1: GP/matching/schematic, simulator spectre
  Models: /home/islam/Cadence/PDK_22FDX-EXT_V1.0_3.0_-_DOCUMENTS_----_NOTE_-SYNOPSYS_CUSTOMCOMPILER-IPDK_IS_AVAILABLE._CONTACT_GF_FAE2021911T4576512/Models/Spectre/models/design_wrapper_mmw.lib.scs[tt_pre]
  Temperature: 27
  Simulator options: additionalArgs=vdsatmod=gds
  Analysis sp: start=0.4G stop=8G step=0.1G
  Output S11 dB20 = db(spm('sp 1 1))
  Output S11 = spm('sp 1 1)
  Output S21 dB20 = db(spm('sp 2 1))
Run mode: Single Run, Sweeps and Corners
Global variables:
  wireopt = 19
