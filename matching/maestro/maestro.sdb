ADE simulation setup
Run mode: Single Run, Sweeps and Corners
Tests:
  GP:matching:1: GP/matching/schematic, simulator spectre
Global variables:
  wireopt = 19
