ADE simulation setup
Test GP:Switch:1: GP/Switch/schematic, simulator spectre
  Models: /home/islam/Cadence/PDK_22FDX-EXT_V1.0_3.0_-_DOCUMENTS_----_NOTE_-SYNOPSYS_CUSTOMCOMPILER-IPDK_IS_AVAILABLE._CONTACT_GF_FAE2021911T4576512/Models/Spectre/models/design_wrapper_mmw.lib.scs[tt_pre]
  Variables: Fin = 8G; Pin = -40; L = 20n; Mul = 1; NF = 20; WF = 2u; Vcontrol = 1.8
  Temperature: 27
  Simulator options: additionalArgs=vdsatmod=gds
  Analysis sp: start=0.4G stop=8G step=0.1G oprobe=/PORT1 iprobe=/PORT0 ports=("/PORT1" "/PORT0") donoise=yes
  Analysis dc: (saves the operating point)
  Analysis hb: fundfreqs=("(Fin)") maxharms=("5") tstab=auto errpreset=moderate
  Output S11 dB20 = db(spm('sp 1 1))
  Output S21 dB20 = db(spm('sp 2 1))
  Output S22 dB20 = db(spm('sp 2 2))
  Output S12 dB20 = db(spm('sp 1 2))
  Output OP1dB = value(_drplCompressionPointCurve("Output-referred") 1)
Run mode: Single Run, Sweeps and Corners
Global variables:
  wireopt = 19
Setup values for test GP:Switch:1: Vcontrol = 1.8 0
