ADE simulation setup
Run mode: Single Run, Sweeps and Corners
Tests:
  GP:Switch:1: GP/Switch/schematic, simulator spectre
    Variables: Vcontrol = 1.8 0; Mul = 1; NF = 20; WF = 2u; L = 20n; Fin = 8G; Pin = -40
Global variables:
  wireopt = 19
