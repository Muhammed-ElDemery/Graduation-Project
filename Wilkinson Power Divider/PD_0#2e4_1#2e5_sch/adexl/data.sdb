ADE simulation setup
Run mode: Single Run, Sweeps and Corners
Tests:
  GP_PowerDivider:PD_0.4_1.5_sch:1: GP_PowerDivider/PD_0.4_1.5_sch/schematic, simulator spectre
    Outputs: max S22; max S23
Global variables:
  wireopt = 19
  L = 30u:1u:35u (off)
  W = 70u:1u:80u (off)
  LRes = 1u:0.1u:1.5u (off)
  MOS = "tt_pre"
  WRes = 400n:10n:500n (off)
  Mul = 2:1:5 (off)
Corners:
  SS: temperature=85; MOS="ss_pre"
  ff: temperature=-40; MOS="ff_pre"
Specs:
  GP_PowerDivider:PD_0.4_1.5_sch:1 / max S22: < -10
  GP_PowerDivider:PD_0.4_1.5_sch:1 / max S11: < -10
  GP_PowerDivider:PD_0.4_1.5_sch:1 / max S23: < -10
