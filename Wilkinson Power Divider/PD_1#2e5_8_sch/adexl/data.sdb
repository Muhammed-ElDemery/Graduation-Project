ADE simulation setup
Run mode: Single Run, Sweeps and Corners
Tests:
  GP_PowerDivider:PD_1.5_8_sch:1: GP_PowerDivider/PD_1.5_8_sch/schematic, simulator spectre
    Outputs: ymax(db(spm('sp 1 1))); S22 max; S23 max
Global variables:
  wireopt = 19
  MOS = "tt_pre"
  L = 25u:1u:35u (off)
  W = 25u:1u:35u (off)
  Lr = 1u:0.1u:2u (off)
  Wr = 550n:10n:750n (off)
Corners:
  ss: temperature=85; MOS="ss_pre"
  ff: temperature=-40; MOS="ff_pre"
Specs:
  GP_PowerDivider:PD_1.5_8_sch:1 / S11 max: < -10
  GP_PowerDivider:PD_1.5_8_sch:1 / S22 max: < -10
  GP_PowerDivider:PD_1.5_8_sch:1 / S23 max: < -10
