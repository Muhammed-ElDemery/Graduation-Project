ADE simulation setup
Run mode: Single Run, Sweeps and Corners
Tests:
  GP_PowerDivider:PD_1.5_8_sch:1: GP_PowerDivider/PD_1.5_8_sch/schematic, simulator spectre
    Outputs: ymax(db(spm('sp 1 1))); S22 max; S23 max; S21 max
Global variables:
  wireopt = 19
  MOS = "tt_pre"
  L = 29u (off)
  W = 41u (off)
  Lr = 2.1u (off)
  Wr = 780n (off)
  Mul = 1 (off)
Corners:
  ss: temperature=85; MOS="ss_pre"
  ff: temperature=-40; MOS="ff_pre"
Specs:
  GP_PowerDivider:PD_1.5_8_sch:1 / S11 max: < -8
  GP_PowerDivider:PD_1.5_8_sch:1 / S22 max: < -8
  GP_PowerDivider:PD_1.5_8_sch:1 / S23 max: < -10, weight 5
  GP_PowerDivider:PD_1.5_8_sch:1 / S21 max: > -4.5, weight 2
