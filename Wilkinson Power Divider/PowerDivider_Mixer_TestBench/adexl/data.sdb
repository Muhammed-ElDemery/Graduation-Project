ADE simulation setup
Run mode: Single Run, Sweeps and Corners
Tests:
  GP_PowerDivider:PowerDivider_Mixer_TestBench:1: GP_PowerDivider/PowerDivider_Mixer_TestBench/schematic, simulator spectre
Global variables:
  wireopt = 19
  Vc = 0
  Vcb = 1.32
