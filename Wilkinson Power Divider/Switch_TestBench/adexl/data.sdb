ADE simulation setup
Run mode: Single Run, Sweeps and Corners
Tests:
  GP_PowerDivider:Switch_TestBench:1: GP_PowerDivider/Switch_TestBench/schematic, simulator spectre
    Outputs: S11 max; S21 max
Global variables:
  wireopt = 19
  NF = 64
  Vc = 1.32
  WF = 2u
  MOS = "tt_pre"
  f1 = 4.2G (off)
  Pin = -10 (off)
Corners:
  ss: temperature=85; MOS="ss_pre"
  ff: temperature=-40; MOS="ff_pre"
Specs:
  GP_PowerDivider:Switch_TestBench:1 / S11 max: < -10
  GP_PowerDivider:Switch_TestBench:1 / S21 max: > -0.5
