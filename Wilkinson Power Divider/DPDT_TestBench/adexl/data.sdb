ADE simulation setup
Run mode: Single Run, Sweeps and Corners
Tests:
  GP_PowerDivider:DPDT_TestBench:1: GP_PowerDivider/DPDT_TestBench/schematic, simulator spectre
    Outputs: S31 min; S32 min; Isolation
Global variables:
  wireopt = 19
  f1 = 4G (off)
  NF = 40
  pin = -10
  Vc = 1.32
  Vc_bar = 0
  WF = 2u
  MOS = "tt_pre"
Corners:
  ss: temperature=85; MOS="ss_pre"
  ff: temperature=-40; MOS="ff_pre"
