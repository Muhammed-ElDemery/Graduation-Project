ADE simulation setup
Run mode: Single Run, Sweeps and Corners
Tests:
  Graduation_project:SAR_LOGIC_TESTBENCH:1: Graduation_project/SAR_LOGIC_TESTBENCH/schematic, simulator spectre
    Outputs: COMP; CLK; RESET; B0; B1; VT("/B<0>"); B2; B3; B4; B5; B6; B7; B8; B9; BB9; Test<0>; Test<1>; Test<2>; Test<3>; Test<4>; Test<5>; EOC
Global variables:
  wireopt = 19
  TCLK = 100n
  TRF = 10p
  TS = 1.2u
  VDD = 800m
  VCOMP = 800m
  Muln = 1
  Mulp = 1
  NFn = 64
  NFp = 64
