ADE simulation setup
Run mode: Monte Carlo Sampling
Tests:
  Graduation_project:TSPC_DFF_Cell:1: Graduation_project/TSPC_DFF_Cell/schematic, simulator spectre
    Outputs: Set; Reset; D; OUT; VT("/"); OUTB; CLK; Delay LH
Global variables:
  wireopt = 19
  Ton = 5n
  Ts = 10n
  VDD = 800m
  Muln = 1
  Mulp = 2
  NFn = 100
  NFp = 100
Corners:
  model folders: /home/islam/Cadence/PDK_22FDX-EXT_V1.0_3.0_-_DOCUMENTS_----_NOTE_-SYNOPSYS_CUSTOMCOMPILER-IPDK_IS_AVAILABLE._CONTACT_GF_FAE2021911T4576512/Models/Spectre/models
  C0: temperature=125; design_wrapper_mmw.lib.scs[ff_pre]
  C1: temperature=-40; design_wrapper_mmw.lib.scs[ss_pre]
Monte Carlo Sampling options: mcmethod=all, mcnumpoints=100
