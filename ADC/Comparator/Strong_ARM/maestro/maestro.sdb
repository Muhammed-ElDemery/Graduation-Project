ADE simulation setup
Run mode: Monte Carlo Sampling
Tests:
  SAR:Strong_ARM:1: SAR/Strong_ARM/schematic, simulator spectre
    Variables: wireopt = 19; NPTS = 100; Rsig = 100; TCLK = 0.4n; TRF = 1p; VCM = VDD/2; VDD = 0.8; VIN = 0.7m; VIND = 10m; VOS = 0
    Outputs: delay
Global variables:
  wireopt = 19
Monte Carlo Sampling options: ignoremode=default, mcnumpoints=500, yeyistostart=3.0, reliabilitymode=singlestress, mcSigmaTarget=3, sssnumpoints=7000, yeexpectedyield=3, mcmethod=mismatch, wcdinitialpoints=200, yeiterations=10, yeusehistorymc=0, yeuseautomcsamples=1, yecreatecorners=0, haveyeyieldtostart=1, yeusevarreduction=1
