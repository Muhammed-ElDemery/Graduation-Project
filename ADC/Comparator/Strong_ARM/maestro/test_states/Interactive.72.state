ADE simulation setup
Test SAR:Strong_ARM:1: SAR/Strong_ARM/schematic, simulator spectre
  Models: /home/islam/Cadence/PDK_22FDX-EXT_V1.0_3.0_-_DOCUMENTS_----_NOTE_-SYNOPSYS_CUSTOMCOMPILER-IPDK_IS_AVAILABLE._CONTACT_GF_FAE2021911T4576512/Models/Spectre/models/design_wrapper_mmw.lib.scs[tt_pre]
  Variables: VIND = 10m; VOS = 0; NPTS = 100; Rsig = 100; TCLK = 0.4n; TRF = 1p; VDD = 0.8; VIN = 0.7m; wireopt = 19; VCM = VDD/2
  Temperature: 27
  Simulator options: additionalArgs=vdsatmod=gds
  Analysis tran: stop=2*VAR("TCLK") errpreset=conservative
  Output CLK = v("/CLK" ?result "tran")
  Output OUTP = v("/OUTP" ?result "tran")
  Output OUTN = v("/OUTN" ?result "tran")
  Output OUTDIFF = v("/OUTDIFF" ?result "tran")
  Output INDIFF = v("/INDIFF" ?result "tran")
  Output delay = delay(?wf1 VT("/CLK") ?value1 0.8 ?edge1 "rising" ?nth1 1 ?td1 0.0 ?wf2 abs(VT("/OUTDIFF")) ?value2 0.785 ?edge2 "either" ?nth2 1 ?td2 nil ?stop nil ?multiple nil)
  Output no = drVectorLength(drGetWaveformYVec(cross(OUTDIFF -0.7 1 "falling" t "cycle" nil))) (unticked)
  Output offset = value(VT("/VOS") ymax(xval(VT("/VOS")))) (unticked)
