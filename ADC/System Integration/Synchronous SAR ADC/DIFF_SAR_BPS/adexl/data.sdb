ADE simulation setup
Run mode: Single Run, Sweeps and Corners
Tests:
  Graduation_project:DIFF_SAR_BPS:1: Graduation_project/DIFF_SAR_BPS/schematic, simulator spectre
    Outputs: COMPP; COMPN; Vin; VDACP; VDACN
Global variables:
  wireopt = 19
  FIN = 0
  FS = 50M
  Muln = 1
  Mulp = 1
  nfet = 0
  NFn = 64
  NFp = 64
  pfet = 0
  SW_POS = 2
  TCLK = (1/FS)/12
  TRF = 10p
  VCM = 400m
  VDD = 800m
  Vin = 0
  TSTOP = 1.2*(1/FS)
  Vinn = VCM-0.5*Vdiff_toggle
  Vinp = VCM+0.5*Vdiff_toggle
  Vdiff_toggle = -VDD+(682*(1.6/1024))
  Cu = 30f
  CB = Cu
  VID = Vdiff_toggle
  TR = 10p
  slvtnfet = 0
  slvtpfet = 0
Corners (nominal off):
  model folders: /home/islam/Cadence/PDK_22FDX-EXT_V1.0_3.0_-_DOCUMENTS_----_NOTE_-SYNOPSYS_CUSTOMCOMPILER-IPDK_IS_AVAILABLE._CONTACT_GF_FAE2021911T4576512/Models/Spectre/models
  C0 (off): temperature=-40; design_wrapper_mmw.lib.scs[ss_pre]
  C1: temperature=125; design_wrapper_mmw.lib.scs[ff_pre]
