ADE simulation setup
Run mode: Single Run, Sweeps and Corners
Tests:
  Graduation_project:razavi_bootstrap:1: Graduation_project/razavi_bootstrap/schematic, simulator spectre
    Outputs: VTH; Vout_ac; CLK; Vcap; VINP; Vswitch; Diff CB; VOUTP
Global variables:
  wireopt = 19
  Fin = (Ncyc/Nfft)/Ts
  Ton = 0.5*Ts
  Ts = 1.25n
  Ncyc = 251
  Nfft = 1024
  Tstop = Ncyc/Fin+Tdrop
  Tdrop = Ncyc/Fin
Corners:
  model folders: /home/islam/Cadence/PDK_22FDX-EXT_V1.0_3.0_-_DOCUMENTS_----_NOTE_-SYNOPSYS_CUSTOMCOMPILER-IPDK_IS_AVAILABLE._CONTACT_GF_FAE2021911T4576512/Models/Spectre/models
  C0 (off): design_wrapper_mmw.lib.scs[ss_pre]
Single Run, Sweeps and Corners options: submitpointsenabled=0
