ADE simulation setup
Test GP:LNA_first_stage_feedback:1: GP/LNA_first_stage_feedback/schematic, simulator spectre
  Models: /home/islam/Cadence/PDK_22FDX-EXT_V1.0_3.0_-_DOCUMENTS_----_NOTE_-SYNOPSYS_CUSTOMCOMPILER-IPDK_IS_AVAILABLE._CONTACT_GF_FAE2021911T4576512/Models/Spectre/models/design_wrapper_mmw.lib.scs[tt_pre]
  Variables: Re = 30; Cin = 430f; Cout = 420f; Lin = 57p; Lout = 15p; Vback = 0; LM = 60p; theta = 5; r = 0.1; Fin = 8G; Pin = -50; J = 280; Cc = 1.5p; Cf = 4p; IBias = "VAR(\"J\")*VAR(\"NF\")*VAR(\"WF\")*VAR(\"Mul\")"; LG = 450p; LS = 10p; Mul = 4; Mul_casc = 1; NF = 80; NF_casc = 66; Q = 7; Rf = 1000; Vbias = 1.1; VNF = 2; VNF_casc = 3; WF = 0.6u; WF_casc = 2.6u
  Temperature: 27
  Simulator options: additionalArgs=vdsatmod=gds
  Analysis sp: start=0.4G stop=8G step=0.1G oprobe=/PORT1 iprobe=/PORT0 ports=("/PORT0" "/PORT1") donoise=yes
  Analysis hb: sweep Pin start=-50 stop=0 sweepStep=2 fundfreqs=("(Fin)" "(Fin+200M)") maxharms=("5" "7") tstab=auto errpreset=conservative
  Analysis dc: (saves the operating point)
  Output S21 dB20 = db(spm('sp 2 1))
  Output S11 = spm('sp 1 1)
  Output S11 dB20 = db(spm('sp 1 1))
  Output S12 dB20 = db(spm('sp 1 2))
  Output S22 dB20 = db(spm('sp 2 2))
  Output NF dB10 = db10(getData("F" ?result "sp_noise"))
  Output NFmin dB10 = db10(getData("Fmin" ?result "sp_noise"))
  Output Kf = kf(sp(1 1 ?result "sp") sp(1 2 ?result "sp") sp(2 1 ?result "sp") sp(2 2 ?result "sp"))
  Output Compression Vs Pout = waveVsWave(?y (tangent(dBm(pvi('hb "/net17" "/gnd!" "/PORT1/PLUS" 0 '(1)))) - dBm(pvi('hb "/net17" "/gnd!" "/PORT1/PLUS" 0 '(1)))) ?x dBm(pvi('hb "/net17" "/gnd!" "/PORT1/PLUS" 0 '(1))) ?xName "Pout" ?xUnits "dBm" ?yName "Compression" ?yUnits "dB") (unticked)
  Output Pout = dbm(pvi('hb "/net17" "/gnd!" "/PORT1/PLUS" 0 '(1))) (unticked)
  Output 1st Order freq = "cadar(setof(x harmonicFreqList(?result \"hb_mt_fi\") equal(car(x) '(1 0))))" (unticked)
  Output ipnCurves = ipnVRICurves((v("/net17" ?result "hb_mt_fi") - 0.0) '(2 -1) '(1 0) ?iport i("/PORT1/PLUS" ?result "hb_mt_fi") ?epoint -20 ?psweep nil) (unticked)
  Output Gain = ymin(db(spm('sp 2 1)))
  Output NF = ymax(db10(getData("F" ?result "sp_noise")))
  Output Gmax dB10 = db10(gmax(sp(1 1 ?result "sp") sp(1 2 ?result "sp") sp(2 1 ?result "sp") sp(2 2 ?result "sp")))
  Output OIP3 = ipnVRI((v("/net022" ?result "hb_mt_fi") - v("/net037" ?result "hb_mt_fi")) '(2 -1) '(1 0) ?iport i("/PORT1/PLUS" ?result "hb_mt_fi") ?epoint -40 ?measure "Output")
  Output Output Referred IP3 Points = ipnVRI((v("/net022" ?result "hb_mt_fi") - v("/net037" ?result "hb_mt_fi")) '(2 -1) '(1 0) ?iport i("/PORT1/PLUS" ?result "hb_mt_fi") ?epoint -40 ?psweep nil ?measure "Output")
