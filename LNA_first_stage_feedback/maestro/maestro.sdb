ADE simulation setup
Run mode: Single Run, Sweeps and Corners
Tests:
  GP:LNA_first_stage_feedback:1: GP/LNA_first_stage_feedback/schematic, simulator spectre
    Variables: IBias = VAR("J")*VAR("NF")*VAR("WF")*VAR("Mul"); Cc = 0.8p; LG = 400p; LS = 10p; LM = 60p; J = 280; Rf = 950; Cf = 2p; Mul = 4; Mul_casc = 1; NF = 80; NF_casc = 66; Q = 7; Vbias = 1.1; VNF = 2; VNF_casc = 3; WF = 0.6u; WF_casc = 2.6u; Fin = 8G; Pin = -50; r = 0.1; theta = 5; Vback = 0; Cin = 450f; Cout = 450f; Re = 35; Lswitch = 20n; Mul_switch = 1; NF_Switch = 80; Vcontrol = 0; WF_switch = 5u
    Outputs: NF
Global variables:
  wireopt = 19
Corners:
  model folders: /home/islam/Cadence/PDK_22FDX-EXT_V1.0_3.0_-_DOCUMENTS_----_NOTE_-SYNOPSYS_CUSTOMCOMPILER-IPDK_IS_AVAILABLE._CONTACT_GF_FAE2021911T4576512/Models/Spectre/models
  Hot_tt (off): temperature=80; design_wrapper_mmw.lib.scs[tt_pre]
  Cold_tt (off): temperature=-40; design_wrapper_mmw.lib.scs[tt_pre]
  Hot_ff (off): temperature=80; design_wrapper_mmw.lib.scs[ff_pre]
  Cold_ff (off): temperature=-40; design_wrapper_mmw.lib.scs[ff_pre]
  Hot_ss (off): temperature=80; design_wrapper_mmw.lib.scs[ss_pre]
  Cold_ss (off): temperature=-40; design_wrapper_mmw.lib.scs[ss_pre]
Specs:
  GP:LNA_first_stage_feedback:1 / Gain: > 23
  GP:LNA_first_stage_feedback:1 / NF: < 1
  GP:LNA_first_stage_feedback:1 / OIP3: > 25
