ADE simulation setup
Test GP_lib:test_bench_OTA:1: GP_lib/test_bench_OTA/schematic, simulator spectre
  Models: /home/islam/Cadence/PDK_22FDX-EXT_V1.0_3.0_-_DOCUMENTS_----_NOTE_-SYNOPSYS_CUSTOMCOMPILER-IPDK_IS_AVAILABLE._CONTACT_GF_FAE2021911T4576512/Models/Spectre/models/design_wrapper_mmw.lib.scs[tt_pre], /home/islam/Cadence/save.scs
  Variables: VB = 0.440; wireopt = 19; L = 100n; NF_LOAD_P = 2; NF_N = 8; VDS = 1.2; VGS = 0.35; W_LOAD_P = 3.5u*1; WN = 16u*1; VCASC = 1; WN_CASC = 4u; L_reg = 30n; FACTOR = 2; WP = 14u*FACTOR; NF_P = 2*FACTOR; W_LOAD_N = 1u*FACTOR; NF_LOAD_N = 1*FACTOR; W_SOURCE = 1u*FACTOR
  Temperature: 27
  Simulator options: additionalArgs=vdsatmod=gds
  Analysis noise: start=1 stop=1G p=/net023 n=/gnd! iprobe=/V1
  Analysis dc: sweep VB start=0.3 stop=0.6 (saves the operating point)
  Output sqrt(integ(pow(getData("/in" ?result "noise") 2) 0 200000000 " "))
  Output (getData("N3:gm" ?result "dcOp") / (getData("P2:gm" ?result "dcOp") + getData("P2:gds" ?result "dcOp") + getData("N3:gds" ?result "dcOp")))
  Output Total_C_ID = ((getData("N3:cdd" ?result "dc") + getData("P2:cdd" ?result "dc") + getData("P2:cgg" ?result "dc")) / (getData("N3:id" ?result "dc")))
  Output W_ID_N = (pv("N3" "w" ?result "instance") / getData("N3:id" ?result "dc"))
  Output W_ID_P = ((-1 * pv("P2" "w" ?result "instance")) / getData("P2:id" ?result "dc"))
  Output (getData("N3:gm" ?result "dc") / (getData("P2:gm" ?result "dc") + getData("P2:gds" ?result "dc") + getData("P2:gds" ?result "dc")))
  Output ((getData("N3:cdd" ?result "dc") + getData("P2:cdd" ?result "dc") + getData("P2:cgg" ?result "dc")) / getData("N3:id" ?result "dc"))
  Output (getData("P3:gm" ?result "dc") / (getData("N5:gm" ?result "dc") + getData("N5:gds" ?result "dc") + getData("P3:gds" ?result "dc")))
  Output GAIN = ((getData("N3:gm" ?result "dcOp") * getData("N4:gm" ?result "dcOp")) / (getData("P2:gm" ?result "dcOp") + getData("P2:gds" ?result "dcOp") + getData("N4:gds" ?result "dcOp")) / (getData("N4:gm" ?result "dcOp") + getData("N3:gds" ?result "dcOp"))) (unticked)
  Output ((-1 * pv("P3" "w" ?result "instance")) / getData("P3:id" ?result "dc"))
  Output (getData("P3:gm" ?result "dcOp") / (getData("N5:gm" ?result "dcOp") + getData("N5:gds" ?result "dcOp") + getData("P3:gds" ?result "dcOp")))
Run mode: Single Run, Sweeps and Corners
Global variables:
  wireopt = 19
