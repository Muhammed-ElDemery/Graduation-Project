ADE simulation setup
Test GP_lib:filter_test:1: GP_lib/filter_test/config, simulator spectre
  Models: /home/islam/Cadence/PDK_22FDX-EXT_V1.0_3.0_-_DOCUMENTS_----_NOTE_-SYNOPSYS_CUSTOMCOMPILER-IPDK_IS_AVAILABLE._CONTACT_GF_FAE2021911T4576512/Models/Spectre/models/design_wrapper_mmw.lib.scs[tt_pre]
  Variables: NF_P_input = 30; CD_ADDED = 0; wireopt = 19; LN = 200n; LN1 = 60n; LP = 700n; LP1 = 60n; NF_N = 12*4; NF_P = 16*4; VBP = 1.076; VOCM = 0.7; VINCM = 0.7; AV = 257; AV2 = 100; C_first_stage = 8.6f+2.3f; C_miller = 1.92f; GM2 = 0.6219m; C_stab = 0; COUT = 16f; ROUT = 108.66k; R = 0.3; FACTOR = 10; VPK = 1m; frq = 100M; LN1_CASC = 20n; VCASC = 1.2; C_LPF = 6p; LN2 = 200n*2; LP2 = 100n; LP_CASC = 20n; NF_N2 = 16; NF_P2 = 8; NF_P_CASC = 32; VCASCP = 0.8; K = 2; K2 = 0.3; LP_input = 500n; WP_input = 80u; K3 = 2.5; Rdgen = 0; LN_input = 500n*K2; NF_N_input = 100*K; WN_input = 280u*K*K2; ISS_input = 1.65m*K; Rdegen_input = (K-1)/(K*12.9m); NF_P_input2 = NF_P_input*2; ISS = 200u*FACTOR; ISS1 = 1m*FACTOR*R; NF_N1 = 2*FACTOR; NF_P1 = 2*FACTOR; WN = 5.1u*FACTOR; WN1 = 8u*FACTOR*R*2; WP = 37.5u*FACTOR; WP1 = 3u*FACTOR*R*2; GM = 1.98*GM2*0.5*FACTOR; GM_first_stage = 8.976m*R; R_first_stage = 227*1/R; C_par = 30f*FACTOR; CGD_1 = 15f*R; CIN = 33f*R; WN1_CASC = 5u*FACTOR*R; WN2 = 45u/8*FACTOR*2; WP2 = 24u/8*FACTOR; WP_CASC = 40u/8*FACTOR*K3; WP_input2 = WP_input*2; Rdgen_Q = Rdgen/3; NF_N_input2 = NF_N_input*2; WN_input2 = WN_input*2; ISS_input2 = ISS_input*2; C_1 = 2*GM*7.829e-10-C_par-2*CD_ADDED; C_2 = 2*GM*11.096e-10-C_par-2*CD_ADDED; C_3 = 2*GM*2.92e-10; C_4 = 2*GM*5.465e-10; C_5 = 2*GM*3.938e-10-C_par-2*CD_ADDED; L_1 = 2*GM*4.922e-10-C_par-2*CD_ADDED; L_2 = 2*GM*5.048e-10-C_par-2*CD_ADDED
  Temperature: 27
  Simulator options: additionalArgs=vdsatmod=gds
  Analysis dc: (saves the operating point)
  Analysis ac: start=100M stop=1G
  Analysis hb: fundfreqs=("(frq)" "(frq+10M)") maxharms=("3" "3") tstab=auto errpreset=liberal
  Analysis noise: start=1 stop=1G p=/VOUTP n=/VOUTN iprobe=/PORT0
  Output v /VOUT; ac dB20(V) = db(vfreq('ac "/VOUT"))
  Output Noise_up_to_200M = sqrt(integ(VN2("/home/islam/simulation/GP_lib/filter_test/maestro/results/maestro/ExplorerRun.0/1/GP_lib:filter_test:1") 0 200000000 " "))
  Output ((1.5 * value(db20(v("/VOUT" ?result "hb_mt_fi")) 100000000)) - (value(db20(v("/VOUT" ?result "hb_mt_fi")) 90000000) * 0.5))
  Output 1st Order freq = "cadar(setof(x harmonicFreqList(?result \"hb_mt_fi\") equal(car(x) '(1 0))))" (unticked)
  Output v /VOUT; hb_mt dB20(V) = db(vh('hb "/VOUT"))
  Output Noise_full_Band = sqrt(integ(VN2("/home/islam/simulation/GP_lib/filter_test/maestro/results/maestro/ExplorerRun.0/1/GP_lib:filter_test:1") 0 2147483647 " "))
Run mode: Single Run, Sweeps and Corners
Global variables:
  wireopt = 19
Specs:
  GP_lib:filter_test:1 / sqrt(integ(VN2("/home/islam/simulation/GP_lib/filter_test/maestro/results/maestro/ExplorerRun.0/1/GP_lib:filter_test:1") 0 200000000 " ")): < 99.2u
Setup values for test GP_lib:filter_test:1: C_1 = 2*GM*6.635e-10-C_par; C_2 = 2*GM*9.054e-10-C_par; C_3 = 2*GM*2.1e-10; C_4 = 2*GM*7.062e-10; C_5 = 2*GM*4.169e-10-C_par; L_1 = 2*GM*6.317e-10-C_par; L_2 = 2*GM*3.615e-10-C_par; LN1 = 30n; LP1 = 30n; WN1 = 8u*FACTOR*R; WP1 = 3u*FACTOR*R; GM = 2.03*GM2*0.5*FACTOR; GM2 = 0.63m; C_par = 100f*FACTOR; R = 0.4; FACTOR = 8; LN2 = 200n; WN2 = 45u/8*FACTOR; WP_CASC = 40u/8*FACTOR
