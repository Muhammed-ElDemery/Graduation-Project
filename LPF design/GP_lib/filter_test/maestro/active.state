ADE simulation setup
Test GP_lib:filter_test:1: GP_lib/filter_test/config, simulator spectre
  Models: /home/islam/Cadence/PDK_22FDX-EXT_V1.0_3.0_-_DOCUMENTS_----_NOTE_-SYNOPSYS_CUSTOMCOMPILER-IPDK_IS_AVAILABLE._CONTACT_GF_FAE2021911T4576512/Models/Spectre/models/design_wrapper_mmw.lib.scs[tt_pre]
  Variables: LN2 = 200n; LP2 = 100n; LP_CASC = 20n; NF_N2 = 16; NF_P2 = 8; NF_P_CASC = 32; VCASCP = 0.8; C_LPF = 6p; VCASC = 1.2; LN1_CASC = 20n; frq = 100M; VPK = 1m; COUT = 16f; ROUT = 108.66k; AV2 = 100; C_miller = 1.92f; GM2 = 0.63m; AV = 257; VINCM = 0.7; LN = 200n; LN1 = 30n; LP = 700n; LP1 = 30n; NF_N = 12*4; NF_P = 16*4; VBP = 1.076; VOCM = 0.7; wireopt = 19; R = 0.4; C_first_stage = 8.6f+2.3f; FACTOR = 8; C_stab = 0; WP_CASC = 40u/8*FACTOR; WP2 = 24u/8*FACTOR; WN2 = 45u/8*FACTOR; WN1_CASC = 5u*FACTOR*R; NF_P1 = 2*FACTOR; NF_N1 = 2*FACTOR; C_par = 100f*FACTOR; WP1 = 3u*FACTOR*R; WP = 37.5u*FACTOR; WN1 = 8u*FACTOR*R; WN = 5.1u*FACTOR; ISS1 = 1m*FACTOR*R; ISS = 200u*FACTOR; CIN = 33f*R; CGD_1 = 15f*R; R_first_stage = 227*1/R; GM_first_stage = 8.976m*R; GM = 2.03*GM2*0.5*FACTOR; C_5 = 2*GM*4.169e-10-C_par; L_2 = 2*GM*3.615e-10-C_par; L_1 = 2*GM*6.317e-10-C_par; C_2 = 2*GM*9.054e-10-C_par; C_1 = 2*GM*6.635e-10-C_par; C_3 = 2*GM*2.1e-10; C_4 = 2*GM*7.062e-10
  Temperature: 27
  Simulator options: additionalArgs=vdsatmod=gds
  Analysis noise: start=1 stop=1G p=/VOUTP n=/VOUTN iprobe=/PORT0
  Analysis dc: (saves the operating point)
  Analysis ac: start=100M stop=1G
  Output v /VOUT; ac dB20(V) = db(vfreq('ac "/VOUT"))
  Output sqrt(integ(VN2("/home/islam/simulation/GP_lib/filter_test/maestro/results/maestro/ExplorerRun.0/1/GP_lib:filter_test:1") 0 200000000 " "))
  Output ((1.5 * value(db20(v("/VOUT" ?result "hb_mt_fi")) 100000000)) - (value(db20(v("/VOUT" ?result "hb_mt_fi")) 90000000) * 0.5))
Run mode: Single Run, Sweeps and Corners
Global variables:
  wireopt = 19
Specs:
  GP_lib:filter_test:1 / sqrt(integ(VN2("/home/islam/simulation/GP_lib/filter_test/maestro/results/maestro/ExplorerRun.0/1/GP_lib:filter_test:1") 0 200000000 " ")): < 99.2u
