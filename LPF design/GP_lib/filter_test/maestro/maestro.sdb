ADE simulation setup
Run mode: Single Run, Sweeps and Corners
Tests:
  GP_lib:filter_test:1: GP_lib/filter_test/config, simulator spectre
    Variables: wireopt = 19; C_1 = 2*GM*6.635e-10-C_par; C_2 = 2*GM*9.054e-10-C_par; C_3 = 2*GM*2.1e-10; C_4 = 2*GM*7.062e-10; C_5 = 2*GM*4.169e-10-C_par; ISS = 200u*FACTOR; ISS1 = 1m*FACTOR*R; L_1 = 2*GM*6.317e-10-C_par; L_2 = 2*GM*3.615e-10-C_par; LN = 200n; LN1 = 30n; LP = 700n; LP1 = 30n; NF_N = 12*4; NF_N1 = 2*FACTOR; NF_P = 16*4; NF_P1 = 2*FACTOR; VBP = 1.076; VOCM = 0.7; WN = 5.1u*FACTOR; WN1 = 8u*FACTOR*R; WP = 37.5u*FACTOR; WP1 = 3u*FACTOR*R; GM = 2.03*GM2*0.5*FACTOR; VINCM = 0.7; AV = 257; AV2 = 100; C_first_stage = 8.6f+2.3f; C_miller = 1.92f; GM2 = 0.63m; GM_first_stage = 8.976m*R; R_first_stage = 227*1/R; C_par = 100f*FACTOR; C_stab = 0; CGD_1 = 15f*R; CIN = 33f*R; COUT = 16f; ROUT = 108.66k; R = 0.4; FACTOR = 8; VPK = 1m; frq = 100M; LN1_CASC = 20n; WN1_CASC = 5u*FACTOR*R; VCASC = 1.2; C_LPF = 6p; LN2 = 200n; LP2 = 100n; LP_CASC = 20n; NF_N2 = 16; NF_P2 = 8; NF_P_CASC = 32; VCASCP = 0.8; WN2 = 45u/8*FACTOR; WP2 = 24u/8*FACTOR; WP_CASC = 40u/8*FACTOR
Global variables:
  wireopt = 19
Specs:
  GP_lib:filter_test:1 / sqrt(integ(VN2("/home/islam/simulation/GP_lib/filter_test/maestro/results/maestro/ExplorerRun.0/1/GP_lib:filter_test:1") 0 200000000 " ")): < 99.2u
