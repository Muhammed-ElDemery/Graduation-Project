ADE simulation setup
Test GP_lib:test_2nd_stage:1: GP_lib/test_2nd_stage/schematic, simulator spectre
  Models: /home/islam/Cadence/PDK_22FDX-EXT_V1.0_3.0_-_DOCUMENTS_----_NOTE_-SYNOPSYS_CUSTOMCOMPILER-IPDK_IS_AVAILABLE._CONTACT_GF_FAE2021911T4576512/Models/Spectre/models/design_wrapper_mmw.lib.scs[tt_pre], /home/islam/Cadence/save.scs
  Variables: LN = 200n; LP = 100n; LP_CASC = 100n; NF_N = 2; NF_P = 1; NF_P_CASC = 1; VBN = 503m; VCASC = 0.8; VINCM = 1.1; VOCM = 0.6; WN = 2.2u; WP = 1u; WP_CASC = 8u; wireopt = 19
  Temperature: 27
  Simulator options: additionalArgs=vdsatmod=gds
  Analysis ac: start=1 stop=1G
  Analysis dc: sweep VINCM start=1 stop=1.1 (saves the operating point)
  Output v /VOUT; ac mag(V) = vfreq('ac "/VOUT")
  Output i /V4/PLUS; dc (I) = i("/V4/PLUS" ?result "dc")
Run mode: Single Run, Sweeps and Corners
Global variables:
  wireopt = 19
