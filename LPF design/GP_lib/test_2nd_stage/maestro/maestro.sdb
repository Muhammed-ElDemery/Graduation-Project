ADE simulation setup
Run mode: Single Run, Sweeps and Corners
Tests:
  GP_lib:test_2nd_stage:1: GP_lib/test_2nd_stage/schematic, simulator spectre
    Variables: wireopt = 19; LN = 200n; LP = 100n; LP_CASC = 100n; NF_N = 2; NF_P = 1; NF_P_CASC = 1; VBN = 503m; VCASC = 0.8; VINCM = 1.1; VOCM = 0.6; WN = 2.2u; WP = 1u; WP_CASC = 8u
Global variables:
  wireopt = 19
