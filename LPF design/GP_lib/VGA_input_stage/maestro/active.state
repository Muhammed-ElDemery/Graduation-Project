ADE simulation setup
Test GP_lib:VGA_input_stage:1: GP_lib/VGA_input_stage/schematic, simulator spectre
  Models: /home/islam/Cadence/PDK_22FDX-EXT_V1.0_3.0_-_DOCUMENTS_----_NOTE_-SYNOPSYS_CUSTOMCOMPILER-IPDK_IS_AVAILABLE._CONTACT_GF_FAE2021911T4576512/Models/Spectre/models/design_wrapper_mmw.lib.scs[tt_pre], /home/islam/Cadence/save.scs
  Variables: LN2 = 400n; LP2 = 150n; NF_LOAD = 20; VOCM = 0.5; WN_LOAD = 13u*5/4*2; RS = 20; frq = 600M; VAMP = 0.1m; VID = 0; VINCM = 800m; LS = 400n; NF_S = 40; LN = 200n; LP = 300n; VBP = 600m; VGS = 478m; wireopt = 19; FACTOR = 3; multi = 2; RFBK = 150; WP = 150u; RLOAD = 100+RFBK; NF_N = 10*2*FACTOR; NF_P = 10*2*FACTOR; NF_P2 = 10*2*FACTOR; WN = 140u*FACTOR/multi; WP2 = 24.4u*FACTOR; ISS = 2240u*FACTOR; WS = 320u*2*FACTOR
  Temperature: 27
  Simulator options: additionalArgs=vdsatmod=gds
  Analysis ac: start=frq stop=10G
  Analysis dc: sweep VBP start=0.3 stop=0.7 (saves the operating point)
  Analysis noise: start=1 stop=600M p=/OUTP n=/OUTN iprobe=/V4
  Output VINN_density = sqrt((integ((VNIN("/home/islam/simulation/GP_lib/VGA_input_stage/maestro/results/maestro/ExplorerRun.0/1/GP_lib:VGA_input_stage:1")**2) 0 600000000 " ") / 600000000))
  Output gm_ID_N = (getData("N0:gm" ?result "dc") / getData("N0:id" ?result "dc"))
  Output GAIN = (getData("N0:gm" ?result "dc") / (getData("P0:gds" ?result "dc") + getData("N0:gds" ?result "dc") + getData("P0:gm" ?result "dc") + getData("P1:gds" ?result "dc")))
  Output gm_ID_P = ((- getData("P0:gm" ?result "dc")) / getData("P0:id" ?result "dc"))
  Output Linearity = deriv(deriv((getData("N0:gm" ?result "dc") / (getData("P0:gds" ?result "dc") + getData("N0:gds" ?result "dc") + getData("P0:gm" ?result "dc") + getData("P1:gds" ?result "dc")))))
  Output v (/OUTP /OUTN); ac dB20(V) = db((vfreq('ac "/OUTP") - vfreq('ac "/OUTN")))
  Output ipnCurves = ipnVRICurves((v("/OUTP2" ?result "hb_mt_fi") - v("/OUTN2" ?result "hb_mt_fi")) '(2 -1) '(1 0) ?rport 100 ?epoint -50)
  Output Output Referred IP3 Point = ipnVRI((v("/OUTP" ?result "hb_mt_fi") - v("/OUTN" ?result "hb_mt_fi")) '(2 -1) '(1 0) ?rport 100 ?epoint -50 ?measure "Output")
  Output 1st Order freq = "cadar(setof(x harmonicFreqList(?result \"hb_mt_fi\") equal(car(x) '(1 0))))" (unticked)
  Output v (/OUTP2 /OUTN2); ac dB20(V) = db((vfreq('ac "/OUTP2") - vfreq('ac "/OUTN2")))
  Output (db((vfreq('ac "/OUTP2") - vfreq('ac "/OUTN2"))) - db((vfreq('ac "/VINP") - vfreq('ac "/VINN"))))
Run mode: Single Run, Sweeps and Corners
Setup values for test GP_lib:VGA_input_stage:1: LN = 400n; LP = 400n; NF_N = 20; NF_P = 10; NF_P2 = 10; VBP = 0.6; WN = 160u*FACTOR; WP = 5u*4*2*FACTOR; WP2 = 10u*4*1.5*FACTOR; ISS = 1741u*FACTOR; WS = 320u*FACTOR; FACTOR = 1
