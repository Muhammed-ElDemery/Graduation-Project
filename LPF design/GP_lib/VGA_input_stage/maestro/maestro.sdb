ADE simulation setup
Run mode: Single Run, Sweeps and Corners
Tests:
  GP_lib:VGA_input_stage:1: GP_lib/VGA_input_stage/schematic, simulator spectre
    Variables: wireopt = 19; LN = 400n; LP = 400n; NF_N = 20; NF_P = 10; NF_P2 = 10; VBP = 0.6; VGS = 478m; WN = 160u*FACTOR; WP = 5u*4*2*FACTOR; WP2 = 10u*4*1.5*FACTOR; ISS = 1741u*FACTOR; LS = 400n; NF_S = 40; WS = 320u*FACTOR; VINCM = 800m; FACTOR = 1; VID = 0; frq = 600M; VAMP = 0.1m
