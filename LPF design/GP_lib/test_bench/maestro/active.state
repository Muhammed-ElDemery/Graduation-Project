ADE simulation setup
Test GP_lib:test_bench:1: GP_lib/test_bench/schematic, simulator spectre
  Models: /home/islam/Cadence/PDK_22FDX-EXT_V1.0_3.0_-_DOCUMENTS_----_NOTE_-SYNOPSYS_CUSTOMCOMPILER-IPDK_IS_AVAILABLE._CONTACT_GF_FAE2021911T4576512/Models/Spectre/models/design_wrapper_mmw.lib.scs[tt_pre], /home/islam/Cadence/save.scs
  Variables: LP = 100n; NF_P = 1; WT_P = 1u; L = 100n; NF = 1; VDS = 0.6; VGS = 0.59; W_tot = 1u; wireopt = 19
  Temperature: 27
  Simulator options: additionalArgs=vdsatmod=gds
  Analysis dc: sweep VDS start=0.1 stop=0.8 (saves the operating point)
  Output (getData("N0:gm" ?result "dc") / getData("N0:id" ?result "dc"))
  Output deriv(deriv(getData("N0:gm" ?result "dc")))
  Output deriv(deriv(getData("N1:gm" ?result "dc")))
  Output (getData("N1:gm" ?result "dc") / getData("N1:id" ?result "dc"))
  Output (getData("N1:gm" ?result "dc") / getData("N1:gds" ?result "dc"))
  Output (getData("N0:gm" ?result "dc") / getData("N0:gds" ?result "dc"))
  Output (getData("N0:cgg" ?result "dc") / getData("N0:gm" ?result "dc"))
  Output (getData("N1:cgg" ?result "dc") / getData("N1:gm" ?result "dc"))
  Output (getData("N1:cdd" ?result "dc") / getData("N1:gm" ?result "dc"))
  Output (-10 * log10(abs((deriv(deriv(getData("N1:gm" ?result "dc"))) / getData("N1:gm" ?result "dc")))))
Run mode: Single Run, Sweeps and Corners
Global variables:
  wireopt = 19
