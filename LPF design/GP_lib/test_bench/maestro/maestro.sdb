ADE simulation setup
Run mode: Single Run, Sweeps and Corners
Tests:
  GP_lib:test_bench:1: GP_lib/test_bench/schematic, simulator spectre
    Variables: wireopt = 19; L = 100n; NF = 1; VDS = 0.6; VGS = 0.59; W_tot = 1u; LP = 100n; NF_P = 1; WT_P = 1u
Global variables:
  wireopt = 19
