ADE simulation setup
Run mode: Single Run, Sweeps and Corners
Tests:
  GP_lib:gm_ID_TB:1: GP_lib/gm_ID_TB/schematic, simulator spectre
    Variables: wireopt = 19; LN = 200n; LP = 100n; NF_N = 1; NF_P = 1; VDS = 0.486; VGS = 0.3:0.05:0.5; W_L_N = 10; W_L_P = 10; VSB = 0; LP2 = 200n; W_L_P2 = 10
    Outputs: gm_id_P1; (getData("N0:gm" ?result "dc") / getData("N0:id" ?result "dc")); gm_id_N1; IIP3_N1; gain_N1; gain_P1; gain_N2; IIP3_N2; IIP3_P2; gain_P2; cgg_gm_N2; (getData("N2:gm" ?result "dc") / getData("N2:id" ?result "dc")); (pv("N0" "w" ?result "instance") / getData("N2:id" ?result "dc")); (pv("P2" "w" ?result "instance") / getData("P2:id" ?result "dc")); (pv("N2" "w" ?result "instance") / getData("N2:id" ?result "dc")); sqrt(integ((pv("N2" "total" ?result "noise") / pow(getData("N2:gm" ?result "dcOp") 2)) 0 200000000 " ")); sqrt(integ((pv("P2" "total" ?result "noise") / pow(getData("P2:gm" ?result "dcOp") 2)) 0 200000000 " ")); (getData("P2:gds" ?result "dc") / getData("P2id" ?result "dc")); gds_id_P2; (getData("P0:cdd" ?result "dc") / getData("P2:gm" ?result "dc")); (getData("P2:cdd" ?result "dc") / getData("P2:gm" ?result "dc")); (getData("N2:cdd" ?result "dc") / getData("N2:gm" ?result "dc")); ((- getData("P2:gm" ?result "dc")) / getData("P2:id" ?result "dc")); vinn_P0
  College_Assignments:5T_OTA:1: College_Assignments/5T_OTA/schematic, simulator spectre
    Variables: wireopt = 19; ISS = 200u; LN = 200n; LP = 700n; NF_N = 12; NF_P = 16; VB_P = 438m; VICM = 800m; WN = 5u; WP = 37.5u; VOCM = 1.1; VID = 0; CL = 292.6f; ISS1 = 135u*2; LN1 = 100n; LP1 = 100n; NF_N1 = 8; NF_P1 = 2; WN1 = 8u*2; WP1 = 3.5u*2; VIN_HB = 0.1
  GP_lib:test_bench_OTA:1: GP_lib/test_bench_OTA/schematic, simulator spectre
    Variables: wireopt = 19; L = 100n; L_reg = 20n; NF_LOAD_N = 1; NF_LOAD_P = 1; NF_N = 1; VDS = 1.3; VGS = 0.469; W_LOAD_P = 1u; WLOAD_N = 1u; WN = 2u
Global variables:
  wireopt = 19
