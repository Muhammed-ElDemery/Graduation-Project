ADE simulation setup
Test GP_lib:test_bench_OTA:1: GP_lib/test_bench_OTA/schematic, simulator spectre
  Models: /home/islam/Cadence/PDK_22FDX-EXT_V1.0_3.0_-_DOCUMENTS_----_NOTE_-SYNOPSYS_CUSTOMCOMPILER-IPDK_IS_AVAILABLE._CONTACT_GF_FAE2021911T4576512/Models/Spectre/models/design_wrapper_mmw.lib.scs[tt_pre], /home/islam/Cadence/save.scs
  Variables: L = 100n; L_reg = 20n; NF_LOAD_N = 1; NF_LOAD_P = 1; NF_N = 1; VDS = 1.3; VGS = 0.469; W_LOAD_P = 1u; WLOAD_N = 1u; WN = 2u; wireopt = 19
  Temperature: 27
  Simulator options: additionalArgs=vdsatmod=gds
  Analysis dc: (saves the operating point)
  Output deriv(deriv(getData("N2:gm" ?result "dc")))
Test College_Assignments:5T_OTA:1: College_Assignments/5T_OTA/schematic, simulator spectre
  Models: /home/islam/Cadence/PDK_22FDX-EXT_V1.0_3.0_-_DOCUMENTS_----_NOTE_-SYNOPSYS_CUSTOMCOMPILER-IPDK_IS_AVAILABLE._CONTACT_GF_FAE2021911T4576512/Models/Spectre/models/design_wrapper_mmw.lib.scs[tt_pre], /home/islam/Cadence/save.scs
  Variables: VIN_HB = 0.1; ISS1 = 135u*2; LN1 = 100n; LP1 = 100n; NF_N1 = 8; NF_P1 = 2; WN1 = 8u*2; WP1 = 3.5u*2; CL = 292.6f; VID = 0; VOCM = 1.1; ISS = 200u; LN = 200n; LP = 700n; NF_N = 12; NF_P = 16; VB_P = 438m; VICM = 800m; WN = 5u; WP = 37.5u; wireopt = 19
  Temperature: 27
  Simulator options: additionalArgs=vdsatmod=gds
  Analysis noise: start=1 stop=1G oprobe=/IPRB0 iprobe=/V4
  Analysis ac: start=1 stop=1G
  Analysis dc: (saves the operating point)
  Output AC Rapid IP3 _acip3_sweep_power_=1 Results = rapidIPNCurves("ac_ip3" '"_acip3_sweep_power_" '1) (unticked)
  Output AC Rapid IIP3 _acip3_sweep_power_=1 Results = rapidIIPN("ac_ip3" '"_acip3_sweep_power_" '1) (unticked)
  Output IIP3_dBV = (rapidIIPN("ac_ip3" '"_acip3_sweep_power_" '1) - 10)
  Output i /C0/PLUS; hb dB20(I) = db(rms(ih('hb "/C0/PLUS")))
  Output IIP3_dBV_calculated = ((0.5 * value(db(rms(ih('hb "/C0/PLUS"))) 50000000)) - (0.5 * value(db(rms(ih('hb "/C0/PLUS"))) 150000000)) - 1.76)
  Output input_noise = sqrt(integ(pow(getData("/in" ?result "noise") 2) 0 200000000 " "))
  Output GM = ((getData("N4:gm" ?result "dcOp") / (getData("P2:gm" ?result "dcOp") + getData("P2:gds" ?result "dcOp") + getData("N4:gds" ?result "dcOp"))) * getData("N0:gm" ?result "dcOp"))
  Signals: /IPRB0/PLUS (terminal), /C0/PLUS (terminal)
Test GP_lib:gm_ID_TB:1: GP_lib/gm_ID_TB/schematic, simulator spectre
  Models: /home/islam/Cadence/PDK_22FDX-EXT_V1.0_3.0_-_DOCUMENTS_----_NOTE_-SYNOPSYS_CUSTOMCOMPILER-IPDK_IS_AVAILABLE._CONTACT_GF_FAE2021911T4576512/Models/Spectre/models/design_include2.scs, /home/islam/Cadence/save.scs
  Variables: LP2 = 200n; W_L_P2 = 10; VSB = 0; LN = 200n; LP = 100n; NF_N = 1; NF_P = 1; VDS = 0.486; VGS = 0.513; W_L_N = 10; W_L_P = 10; wireopt = 19
  Temperature: 27
  Simulator options: additionalArgs=vdsatmod=gds
  Analysis noise: start=1 stop=10G oprobe=/IPRB2 iprobe=/V1
  Analysis dc: (saves the operating point)
  Output gm_id_P0 = ((- getData("P0:gm" ?result "dc")) / getData("P0:id" ?result "dc"))
  Output gm_id_P1 = ((- getData("P1:gm" ?result "dc")) / getData("P1:id" ?result "dc"))
  Output gm_id_N0 = (getData("N0:gm" ?result "dc") / getData("N0:id" ?result "dc"))
  Output gm_id_N1 = (getData("N1:gm" ?result "dc") / getData("N1:id" ?result "dc"))
  Output IIP3_N0 = (-10 * log10(abs((deriv(deriv(getData("N0:gm" ?result "dc"))) / getData("N0:gm" ?result "dc")))))
  Output IIP3_N2 = (-10 * log10(abs((deriv(deriv(getData("N2:gm" ?result "dc"))) / getData("N2:gm" ?result "dc")))))
  Output IIP3_P2 = (-10 * log10(abs((deriv(deriv(getData("P2:gm" ?result "dc"))) / getData("P2:gm" ?result "dc")))))
  Output IIP3_N1 = (-10 * log10(abs((deriv(deriv(getData("N1:gm" ?result "dc"))) / getData("N1:gm" ?result "dc")))))
  Output IIP3_P0 = (-10 * log10(abs((deriv(deriv(getData("P0:gm" ?result "dc"))) / getData("P0:gm" ?result "dc")))))
  Output gain_N2 = (getData("N2:gm" ?result "dc") / getData("N2:gds" ?result "dc"))
  Output gain_N1 = (getData("N1:gm" ?result "dc") / getData("N1:gds" ?result "dc"))
  Output gain_N0 = (getData("N0:gm" ?result "dc") / getData("N0:gds" ?result "dc"))
  Output gain_P0 = (getData("P0:gm" ?result "dc") / getData("P0:gds" ?result "dc"))
  Output gain_P1 = (getData("P1:gm" ?result "dc") / getData("P1:gds" ?result "dc"))
  Output gain_P2 = (getData("P2:gm" ?result "dc") / getData("P2:gds" ?result "dc"))
  Output cgg_gm_N2 = (getData("N2:cgg" ?result "dc") / getData("N2:gm" ?result "dc"))
  Output cgg_gm_N0 = (getData("N0:cgg" ?result "dc") / getData("N0:gm" ?result "dc"))
  Output cdd_gm_N0 = (getData("N0:cdd" ?result "dc") / getData("N0:gm" ?result "dc"))
  Output cdd_gm_P0 = (getData("P0:cdd" ?result "dc") / getData("P0:gm" ?result "dc"))
  Output gds_id_N0 = (getData("N0:gds" ?result "dc") / getData("N0:id" ?result "dc"))
  Output gds_id_P0 = (getData("P0:gds" ?result "dc") / getData("P0:id" ?result "dc"))
  Output W_id_N0 = (pv("N0" "w" ?result "instance") / getData("N0:id" ?result "dc"))
  Output W_id_P0 = (pv("P0" "w" ?result "instance") / getData("P0:id" ?result "dc"))
  Output W_id_P1 = (pv("P1" "w" ?result "instance") / getData("P1:id" ?result "dc"))
  Output W_id_N1 = (pv("N1" "w" ?result "instance") / getData("N1:id" ?result "dc"))
  Output (getData("N2:gm" ?result "dc") / getData("N2:id" ?result "dc"))
  Output (pv("N2" "w" ?result "instance") / getData("N2:id" ?result "dc"))
  Output (pv("P2" "w" ?result "instance") / getData("P2:id" ?result "dc"))
  Output vinn_N2 = sqrt(integ((pv("N2" "total" ?result "noise") / pow(getData("N2:gm" ?result "dcOp") 2)) 0 200000000 " "))
  Output sqrt(integ((pv("P2" "total" ?result "noise") / pow(getData("P2:gm" ?result "dcOp") 2)) 0 200000000 " "))
  Output gds_id_P2 = (getData("P2:gds" ?result "dc") / getData("P2:id" ?result "dc"))
  Output (getData("P2:cdd" ?result "dc") / getData("P2:gm" ?result "dc"))
  Output (getData("N2:cdd" ?result "dc") / getData("N2:gm" ?result "dc"))
  Output ((- getData("P2:gm" ?result "dc")) / getData("P2:id" ?result "dc"))
  Output vinn_P0 = sqrt(integ((pv("P0" "total" ?result "noise") / pow(getData("P0:gm" ?result "dcOp") 2)) 0 200000000 " "))
Run mode: Single Run, Sweeps and Corners
Global variables:
  wireopt = 19
Setup values for test GP_lib:gm_ID_TB:1: VGS = 0.3:0.05:0.5
