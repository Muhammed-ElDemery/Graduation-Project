ADE simulation setup
Test GP_lib:gm_ID_TB:1: GP_lib/gm_ID_TB/schematic, simulator spectre
  Models: /home/islam/Cadence/PDK_22FDX-EXT_V1.0_3.0_-_DOCUMENTS_----_NOTE_-SYNOPSYS_CUSTOMCOMPILER-IPDK_IS_AVAILABLE._CONTACT_GF_FAE2021911T4576512/Models/Spectre/models/design_include2.scs, /home/islam/Cadence/save.scs
  Variables: LP2 = 200n; W_L_P2 = 10; VSB = 0; LN = 200n; LP = 100n; NF_N = 1; NF_P = 1; VDS = 0.486; VGS = 0.513; W_L_N = 10; W_L_P = 10; wireopt = 19
  Temperature: 27
  Simulator options: additionalArgs=vdsatmod=gds
  Analysis noise: start=1 stop=10G oprobe=/IPRB2 iprobe=/V1
  Analysis dc: (saves the operating point)
  Output gm_id_P0 = ((- getData("P0:gm" ?result "dc")) / getData("P0:id" ?result "dc"))
  Output gm_id_P1 = ((- getData("P1:gm" ?result "dc")) / getData("P1:id" ?result "dc"))
  Output gm_id_N0 = (getData("N0:gm" ?result "dc") / getData("N0:id" ?result "dc"))
  Output gm_id_N1 = (getData("N1:gm" ?result "dc") / getData("N1:id" ?result "dc"))
  Output IIP3_N0 = (-10 * log10(abs((deriv(deriv(getData("N0:gm" ?result "dc"))) / getData("N0:gm" ?result "dc")))))
  Output IIP3_N2 = (-10 * log10(abs((deriv(deriv(getData("N2:gm" ?result "dc"))) / getData("N2:gm" ?result "dc")))))
  Output IIP3_P2 = (-10 * log10(abs((deriv(deriv(getData("P2:gm" ?result "dc"))) / getData("P2:gm" ?result "dc")))))
  Output IIP3_N1 = (-10 * log10(abs((deriv(deriv(getData("N1:gm" ?result "dc"))) / getData("N1:gm" ?result "dc")))))
  Output IIP3_P0 = (-10 * log10(abs((deriv(deriv(getData("P0:gm" ?result "dc"))) / getData("P0:gm" ?result "dc")))))
  Output gain_N2 = (getData("N2:gm" ?result "dc") / getData("N2:gds" ?result "dc"))
  Output gain_N1 = (getData("N1:gm" ?result "dc") / getData("N1:gds" ?result "dc"))
  Output gain_N0 = (getData("N0:gm" ?result "dc") / getData("N0:gds" ?result "dc"))
  Output gain_P0 = (getData("P0:gm" ?result "dc") / getData("P0:gds" ?result "dc"))
  Output gain_P1 = (getData("P1:gm" ?result "dc") / getData("P1:gds" ?result "dc"))
  Output gain_P2 = (getData("P2:gm" ?result "dc") / getData("P2:gds" ?result "dc"))
  Output cgg_gm_N2 = (getData("N2:cgg" ?result "dc") / getData("N2:gm" ?result "dc"))
  Output cgg_gm_N0 = (getData("N0:cgg" ?result "dc") / getData("N0:gm" ?result "dc"))
  Output cdd_gm_N0 = (getData("N0:cdd" ?result "dc") / getData("N0:gm" ?result "dc"))
  Output cdd_gm_P0 = (getData("P0:cdd" ?result "dc") / getData("P0:gm" ?result "dc"))
  Output gds_id_N0 = (getData("N0:gds" ?result "dc") / getData("N0:id" ?result "dc"))
  Output gds_id_P0 = (getData("P0:gds" ?result "dc") / getData("P0:id" ?result "dc"))
  Output W_id_N0 = (pv("N0" "w" ?result "instance") / getData("N0:id" ?result "dc"))
  Output W_id_P0 = (pv("P0" "w" ?result "instance") / getData("P0:id" ?result "dc"))
  Output W_id_P1 = (pv("P1" "w" ?result "instance") / getData("P1:id" ?result "dc"))
  Output W_id_N1 = (pv("N1" "w" ?result "instance") / getData("N1:id" ?result "dc"))
  Output (getData("N2:gm" ?result "dc") / getData("N2:id" ?result "dc"))
  Output (pv("N2" "w" ?result "instance") / getData("N2:id" ?result "dc"))
  Output (pv("P2" "w" ?result "instance") / getData("P2:id" ?result "dc"))
  Output vinn_N2 = sqrt(integ((pv("N2" "total" ?result "noise") / pow(getData("N2:gm" ?result "dcOp") 2)) 0 200000000 " "))
  Output sqrt(integ((pv("P2" "total" ?result "noise") / pow(getData("P2:gm" ?result "dcOp") 2)) 0 200000000 " "))
  Output gds_id_P2 = (getData("P2:gds" ?result "dc") / getData("P2:id" ?result "dc"))
  Output (getData("P2:cdd" ?result "dc") / getData("P2:gm" ?result "dc"))
  Output (getData("N2:cdd" ?result "dc") / getData("N2:gm" ?result "dc"))
  Output ((- getData("P2:gm" ?result "dc")) / getData("P2:id" ?result "dc"))
  Output vinn_P0 = sqrt(integ((pv("P0" "total" ?result "noise") / pow(getData("P0:gm" ?result "dcOp") 2)) 0 200000000 " "))
