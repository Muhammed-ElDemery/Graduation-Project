ADE simulation setup
Test GP_lib:GM_cell_input_tb:1: GP_lib/GM_cell_input_tb/schematic, simulator spectre
  Models: /home/islam/Cadence/PDK_22FDX-EXT_V1.0_3.0_-_DOCUMENTS_----_NOTE_-SYNOPSYS_CUSTOMCOMPILER-IPDK_IS_AVAILABLE._CONTACT_GF_FAE2021911T4576512/Models/Spectre/models/design_wrapper_mmw.lib.scs[tt_pre], /home/islam/Cadence/save.scs
  Variables: wireopt = 19; ISS = 1.65m; LN = 500n; LP = 100n; NF_N = 20; NF_P = 20; VGSP = 0.5; VINCM = 0.7; VOCM = 0.7; WN = 20u; WP = 20u; ISS_input = 1.65m; LN_input = 100n; LP_input = 100n; NF_N_input = 20*5; NF_P_input = 20*5; WN_input = 80u*5; WP_input = 80u
  Temperature: 27
  Simulator options: additionalArgs=vdsatmod=gds
  Analysis dc: (saves the operating point)
  Analysis noise: start=1 stop=1G p=/VOUTP n=/VOUTN iprobe=/V3
  Output sqrt(integ((VNIN("/home/islam/simulation/GP_lib/GM_cell_input_tb/maestro/results/maestro/ExplorerRun.0/1/GP_lib:GM_cell_input_tb:1")**2) 0 1000000000 " "))
Run mode: Single Run, Sweeps and Corners
Global variables:
  wireopt = 19
