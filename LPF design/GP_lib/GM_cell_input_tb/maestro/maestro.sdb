ADE simulation setup
Run mode: Single Run, Sweeps and Corners
Tests:
  GP_lib:GM_cell_input_tb:1: GP_lib/GM_cell_input_tb/schematic, simulator spectre
    Variables: wireopt = 19; VGSP = 0.5; VINCM = 0.7; VOCM = 0.7; ISS_input = 1.65m*2; LN_input = 500n; LP_input = 500n; NF_N_input = 20*5*2; NF_P_input = 20*5; WN_input = 80u*5*0.7*2; WP_input = 80u; frq = 100M; VPK = 10u; K = 2; GM = 12.9m; Rdegen_input = 38
Global variables:
  wireopt = 19
