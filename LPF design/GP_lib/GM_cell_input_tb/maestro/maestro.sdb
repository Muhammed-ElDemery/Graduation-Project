ADE simulation setup
Run mode: Single Run, Sweeps and Corners
Tests:
  GP_lib:GM_cell_input_tb:1: GP_lib/GM_cell_input_tb/schematic, simulator spectre
    Variables: wireopt = 19; ISS = 1.65m; LN = 500n; LP = 100n; NF_N = 20; NF_P = 20; VGSP = 0.5; VINCM = 0.7; VOCM = 0.7; WN = 20u; WP = 20u; ISS_input = 1.65m; LN_input = 100n; LP_input = 100n; NF_N_input = 20*5; NF_P_input = 20*5; WN_input = 80u*5; WP_input = 80u
Global variables:
  wireopt = 19
