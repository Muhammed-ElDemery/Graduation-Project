ADE simulation setup
Test GP_lib:GM_cell_test:1: GP_lib/GM_cell_test/config, simulator spectre
  Models: /home/islam/Cadence/PDK_22FDX-EXT_V1.0_3.0_-_DOCUMENTS_----_NOTE_-SYNOPSYS_CUSTOMCOMPILER-IPDK_IS_AVAILABLE._CONTACT_GF_FAE2021911T4576512/Models/Spectre/models/design_wrapper_mmw.lib.scs[tt_pre], /home/islam/Cadence/save.scs
  Variables: Rdegen = 8k; LN2 = 200n; LP2 = 100n; LP_CASC = 20n; NF_N2 = 16; NF_P2 = 8; NF_P_CASC = 32; VCASCP = 0.8; WN2 = 45u; WP2 = 24u; WP_CASC = 40u; frq = 100M; VPK = 0.001; AV = 250; GM = 17.16; ISS = 200u*8; ISS1 = 1m*8*0.4; LN = 200n; LN1 = 30n; LP = 700n; LP1 = 30n; NF_N = 12*4; NF_N1 = 16; NF_P = 16*4; NF_P1 = 16; VBP = 1.076; VID = 0; VINCM = 0.7; VOCM = 0.7; WN = 5.1u*8; WN1 = 8u*8*0.4; WP = 37.5u*8; WP1 = 3u*8*0.4; wireopt = 19; CL = GM*2.1e-10
  Temperature: 27
  Analysis noise: start=1 stop=10G p=/VOUTP n=/VOUTN iprobe=/V0
  Analysis dc: sweep VID start=-0.1m stop=0.1m (saves the operating point)
  Analysis ac: start=1 stop=100G
  Analysis hb: fundfreqs=("(frq)") maxharms=("5") tstab=auto errpreset=moderate
  Output i (/IPRB0/PLUS /IPRB1/PLUS); ac dB20(I) = db((ifreq('ac "/IPRB0/PLUS") - ifreq('ac "/IPRB1/PLUS"))) (unticked)
  Output v (/VOUTP /VOUTN); ac mag(V) = (vfreq('ac "/VOUTP") - vfreq('ac "/VOUTN"))
  Output i (/IPRB1/PLUS /IPRB0/PLUS); ac mag(I) = (ifreq('ac "/IPRB1/PLUS") - ifreq('ac "/IPRB0/PLUS")) (unticked)
  Output Noise = sqrt(integ(pow(getData("/in" ?result "noise") 2) 0 200000000 " "))
  Output DC_gain_linear = mag(value((vfreq('ac "/VOUTP") - vfreq('ac "/VOUTN")) 1))
  Output PM = phaseMargin((vfreq('ac "/VOUTP") - vfreq('ac "/VOUTN")))
  Output UGF = unityGainFreq((vfreq('ac "/VOUTP") - vfreq('ac "/VOUTN")))
  Output v (/VOUTP /VOUTN); ac dB20(V) = db((vfreq('ac "/VOUTP") - vfreq('ac "/VOUTN")))
  Output GM = ((getData("N4:gm" ?result "dcOp") / (getData("P2:gm" ?result "dcOp") + getData("P2:gds" ?result "dcOp") + getData("N4:gds" ?result "dcOp"))) * getData("N0:gm" ?result "dcOp"))
  Output OIP3 = ((((value(db((vh('hb "/VOUTP") - vh('hb "/VOUTN"))) 100000000) + (2 * value(db((vh('hb "/VINP") - vh('hb "/VINN"))) 100000000))) - value(db((vh('hb "/VOUTP") - vh('hb "/VOUTN"))) 300000000)) / 2) - 0.256)
  Output v (/I1/VP /I1/VN); ac mag(V) = (vfreq('ac "/I1/VP") - vfreq('ac "/I1/VN"))
  Output v (/VOUTP /VOUTN); dc (V) = (v("/VOUTP" ?result nil) - v("/VOUTN" ?result nil))
Run mode: Single Run, Sweeps and Corners
Global variables:
  wireopt = 19
Setup values for test GP_lib:GM_cell_test:1: VBP = 1.6; VINCM = 0.8; VOCM = 0.8; LN2 = 200n*1.5; NF_N2 = 16*2; WN2 = 45u*1.5; LN3_1 = 30n; LN3_2 = 150n; LP3_1 = 30n; LP3_2 = 700n; NF_N_3_1 = 1; NF_N_3_2 = 4; NF_P_3_1 = 14; NF_P_3_2 = 32; WN3_1 = 2u*FACTOR; WN3_2 = 5.88u*0.75*FACTOR; WP3_1 = 28u*FACTOR; WP3_2 = 71.75u*FACTOR; ISS3_1 = 1.2m*FACTOR; Rdgen = 500; Rdgen_Q = Rdgen/3; WN3_2_P = WN3_2/9*FACTOR; FACTOR = 2
