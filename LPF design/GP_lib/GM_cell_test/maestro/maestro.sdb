ADE simulation setup
Run mode: Single Run, Sweeps and Corners
Tests:
  GP_lib:GM_cell_test:1: GP_lib/GM_cell_test/config, simulator spectre
    Variables: wireopt = 19; CL = GM*2.1e-10; ISS = 200u*8; ISS1 = 1m*8*0.4; LN = 200n; LN1 = 30n; LP = 700n; LP1 = 30n; NF_N = 12*4; NF_N1 = 16; NF_P = 16*4; NF_P1 = 16; VBP = 0.58; VID = 0; VINCM = 0.7; VOCM = 0.7; WN = 5.1u*8; WN1 = 8u*8*0.4; WP = 37.5u*8; WP1 = 3u*8*0.4; AV = 250; GM = 17.16; frq = 100M; VPK = 0.001; LN2 = 200n*1.5; LP2 = 100n; LP_CASC = 20n; NF_N2 = 16*2; NF_P2 = 8; NF_P_CASC = 32; VCASCP = 0.8; WN2 = 45u*1.5; WP2 = 24u; WP_CASC = 40u; LN3_1 = 30n; LN3_2 = 150n; LP3_1 = 30n; LP3_2 = 700n; NF_N_3_1 = 1; NF_N_3_2 = 4; NF_P_3_1 = 14; NF_P_3_2 = 32; WN3_1 = 2u*FACTOR; WN3_2 = 5.88u*0.75*FACTOR; WP3_1 = 28u*FACTOR; WP3_2 = 71.75u*FACTOR; ISS3_1 = 1.2m*FACTOR; Rdgen = 500; Rdgen_Q = Rdgen/3; WN3_2_P = WN3_2/9*FACTOR; FACTOR = 2
    Outputs: DC_gain_linear; GM
Global variables:
  wireopt = 19
