ADE simulation setup
Run mode: Single Run, Sweeps and Corners
Tests:
  GP_lib:GM_cell_test:1: GP_lib/GM_cell_test/config, simulator spectre
    Variables: wireopt = 19; CL = GM*2.1e-10; ISS = 200u*8; ISS1 = 1m*8*0.4; LN = 200n; LN1 = 30n; LP = 700n; LP1 = 30n; NF_N = 12*4; NF_N1 = 16; NF_P = 16*4; NF_P1 = 16; VBP = 1.076; VID = 0; VINCM = 0.7; VOCM = 0.7; WN = 5.1u*8; WN1 = 8u*8*0.4; WP = 37.5u*8; WP1 = 3u*8*0.4; AV = 250; GM = 17.16; frq = 100M; VPK = 0.001; LN2 = 200n; LP2 = 100n; LP_CASC = 20n; NF_N2 = 16; NF_P2 = 8; NF_P_CASC = 32; VCASCP = 0.8; WN2 = 45u; WP2 = 24u; WP_CASC = 40u; Rdegen = 8k
    Outputs: DC_gain_linear; GM
Global variables:
  wireopt = 19
