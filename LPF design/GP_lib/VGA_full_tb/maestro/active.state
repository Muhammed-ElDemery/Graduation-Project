ADE simulation setup
Test GP_lib:VGA_full_tb:1: GP_lib/VGA_full_tb/config, simulator spectre
  Models: /home/islam/Cadence/PDK_22FDX-EXT_V1.0_3.0_-_DOCUMENTS_----_NOTE_-SYNOPSYS_CUSTOMCOMPILER-IPDK_IS_AVAILABLE._CONTACT_GF_FAE2021911T4576512/Models/Spectre/models/design_wrapper_mmw.lib.scs[tt_pre], /home/islam/Cadence/save.scs
  Variables: LNA_NF_P2 = 100; LNA_WP2 = 73.2u; STATE_LNA = 1; R_VGA_0 = 865; R_VGA_1 = 695; R_VGA_2 = 560; R_VGA_3 = 450; R_VGA_4 = 370; R_VGA_5 = 300; R_VGA_6 = 250; L_RES_DAC = 20n; NF_RES_DAC = 60; W_RES_DAC = 60u; WP_BIAS = 66u; C_comp = 300f; VOCM = 0.5; wireopt = 19; CC = 555f; CC_DAC_0 = 385f; CC_DAC_1 = 480f; CC_DAC_2 = 533f; CC_DAC_3 = 550f; CC_DAC_4 = 590f; CC_DAC_5 = 630f; CC_DAC_6 = 690f; CC_DAC_7 = 748f; CC_DAC_8 = 848f; CC_DAC_9 = 960f; CC_DAC_10 = 389f; CC_DAC_11 = 446f; CC_DAC_12 = 509f; CC_DAC_13 = 579f; CC_DAC_14 = 659f; CC_DAC_15 = 748f; frq = 200M; IBias_LNA = 420u; IBias_VGA = 162u/2; L_DAC = 100n; LIP_IN = 100n; LN_in2 = 100n; LN_LOAD1 = 200n; LP_CM = 100n; LP_load2 = 300n; LP_source = 300n; LS_CM = 300n; multi = 2; NF_CM = 20; NF_DAC = 20; NF_in2 = 40; NF_N = 10; NF_N_LOAD1 = 10; NF_P_IN = 80; NF_P_load2 = 200; NF_P_source = 60; NF_S = 20; NF_S_CM = 40; R_feedback = 1.57k; Rz = 50; RZ_DAC = 10; STATE_NOW = 1; VCASCP = 0.324; VGS_VBN = 1.2; VGS_VBP = 600m; VINCM = 0.8; W_DAC = 21u; WN_in2 = 197u; WN_LOAD1 = 44.8u; WP_CM = 11u; WP_IN = 150u; WP_load2 = 1545u; WS = 309u/16; WS_CM = 50.8u; L_source = LP_source; WP_source = WP_load2*0.286
  Temperature: 27
  Simulator options: additionalArgs=vdsatmod=gds
  Analysis ac: start=1 stop=10G
  Analysis dc: (saves the operating point)
  Analysis stb: start=1 stop=10G probe=/I26 stbProbeMode=differential
  Analysis noise: start=1 stop=10G p=/VOP n=/VON iprobe=/V0
  Output VOUT1_AC = db((vfreq('ac "/VO1P") - vfreq('ac "/VO1N")))
  Output VOUT_TOTAL_AC = db((vfreq('ac "/VOP") - vfreq('ac "/VON")))
  Output VOUT_VO!_AC = (db((vfreq('ac "/VOP") - vfreq('ac "/VON"))) - db((vfreq('ac "/VO1P") - vfreq('ac "/VO1N")))) (unticked)
  Output v (/I11/OUTP /I11/OUTN); ac dB20(V) = db((vfreq('ac "/I11/OUTP") - vfreq('ac "/I11/OUTN"))) (unticked)
  Output v (/VO1P /VO1N); ac dB20(V) = db((vfreq('ac "/VO1P") - vfreq('ac "/VO1N"))) (unticked)
  Output Vnin = integ((VNIN("/home/islam/simulation/GP_lib/VGA_full_tb/maestro/results/maestro/ExplorerRun.0/1/GP_lib:VGA_full_tb:1")**2) 0 1.2e+09 " ")
  Output BW = bandwidth((vfreq('ac "/VOP") - vfreq('ac "/VON")) 3 "low")
  Output Loop Gain dB20 = db(mag(getData("loopGain" ?result "stb")))
  Output Phase Margin = getData("phaseMargin" ?result "stb_margin")
  Output ipnCurves = ipnVRICurves((v("/VOP" ?result "hb_mt_fi") - v("/VON" ?result "hb_mt_fi")) '(2 -1) '(1 0) ?rport 100 ?epoint -47)
  Output Output Referred IP3 Point = ipnVRI((v("/VOP" ?result "hb_mt_fi") - v("/VON" ?result "hb_mt_fi")) '(2 -1) '(1 0) ?rport 100 ?epoint -47 ?measure "Output")
  Output 1st Order freq = "cadar(setof(x harmonicFreqList(?result \"hb_mt_fi\") equal(car(x) '(1 0))))" (unticked)
  Output v (/VOP /VON); hb_mt dB20(V) = db((vh('hb "/VOP") - vh('hb "/VON")))
  Output value(db((vfreq('ac "/VOP") - vfreq('ac "/VON"))) 1)
Run mode: Single Run, Sweeps and Corners
Global variables:
  wireopt = 19
Setup values for test GP_lib:VGA_full_tb:1: STATE_LNA = 1:16
