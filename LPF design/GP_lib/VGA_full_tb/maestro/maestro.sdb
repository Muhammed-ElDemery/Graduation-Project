ADE simulation setup
Run mode: Single Run, Sweeps and Corners
Tests:
  GP_lib:VGA_full_tb:1: GP_lib/VGA_full_tb/config, simulator spectre
    Variables: wireopt = 19; CC = 555f; CC_DAC_0 = 385f; CC_DAC_1 = 480f; CC_DAC_2 = 533f; CC_DAC_3 = 550f; CC_DAC_4 = 590f; CC_DAC_5 = 630f; CC_DAC_6 = 690f; CC_DAC_7 = 748f; CC_DAC_8 = 848f; CC_DAC_9 = 960f; CC_DAC_10 = 389f; CC_DAC_11 = 446f; CC_DAC_12 = 509f; CC_DAC_13 = 579f; CC_DAC_14 = 659f; CC_DAC_15 = 748f; frq = 200M; IBias_LNA = 420u; IBias_VGA = 162u/2; L_DAC = 100n; L_source = LP_source; LIP_IN = 100n; LN_in2 = 100n; LN_LOAD1 = 200n; LP_CM = 100n; LP_load2 = 300n; LP_source = 300n; LS_CM = 300n; multi = 2; NF_CM = 20; NF_DAC = 20; NF_in2 = 40; NF_N = 10; NF_N_LOAD1 = 10; NF_P_IN = 80; NF_P_load2 = 200; NF_P_source = 60; NF_S = 20; NF_S_CM = 40; R_feedback = 1.57k; Rz = 50; RZ_DAC = 10; STATE_NOW = 1; VCASCP = 0.324; VGS_VBN = 1.2; VGS_VBP = 600m; VINCM = 0.8; W_DAC = 21u; WN_in2 = 197u; WN_LOAD1 = 44.8u; WP_CM = 11u; WP_IN = 150u; WP_load2 = 1545u; WP_source = WP_load2*0.286; WS = 309u/16; WS_CM = 50.8u; VOCM = 0.5; C_comp = 300f; WP_BIAS = 66u; L_RES_DAC = 20n; NF_RES_DAC = 60; W_RES_DAC = 60u; R_VGA_0 = 865; R_VGA_1 = 695; R_VGA_2 = 560; R_VGA_3 = 450; R_VGA_4 = 370; R_VGA_5 = 300; R_VGA_6 = 250; STATE_LNA = 1:16; LNA_NF_P2 = 100; LNA_WP2 = 73.2u
Global variables:
  wireopt = 19
