ADE simulation setup
Test GP_lib:filter_input_stage_testing:1: GP_lib/filter_input_stage_testing/config, simulator spectre
  Models: /home/islam/Cadence/PDK_22FDX-EXT_V1.0_3.0_-_DOCUMENTS_----_NOTE_-SYNOPSYS_CUSTOMCOMPILER-IPDK_IS_AVAILABLE._CONTACT_GF_FAE2021911T4576512/Models/Spectre/models/design_wrapper_mmw.lib.scs[tt_pre], /home/islam/Cadence/save.scs
  Variables: C_1 = 8p; CD_ADDED = 0; C_LPF = 6p; C_stab = 5p; frq = 100M; LN1 = 60n; LN2 = 200n; LP1 = 60n; LP2 = 100n; LP_CASC = 20n; NF_N2 = 16; NF_P2 = 8; NF_P_CASC = 32; Rdgen = 500; VBP = 1.076; VCASCP = 0.8; VINCM = 0.7; VOCM = 0.7; VPK = 1m; wireopt = 19; FACTOR = 10; R = 0.4; WN2 = 45u/8*FACTOR; WP2 = 24u/8*FACTOR; WP_CASC = 40u/8*FACTOR; WP1 = 3u*FACTOR*R*2; WN1 = 8u*FACTOR*R*2; Rdgen_Q = Rdgen/3; NF_P1 = 2*FACTOR; NF_N1 = 2*FACTOR; ISS1 = 1m*FACTOR*R
  Temperature: 27
  Simulator options: additionalArgs=vdsatmod=gds
  Analysis ac: start=1 stop=100G
  Analysis dc: (saves the operating point)
  Output phaseMargin((vfreq('ac "/VO1P") - vfreq('ac "/VO1N")))
