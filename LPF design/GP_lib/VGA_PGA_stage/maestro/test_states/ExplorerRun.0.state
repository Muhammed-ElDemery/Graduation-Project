ADE simulation setup
Test GP_lib:VGA_PGA_stage:1: GP_lib/VGA_PGA_stage/schematic, simulator spectre
  Models: /home/islam/Cadence/PDK_22FDX-EXT_V1.0_3.0_-_DOCUMENTS_----_NOTE_-SYNOPSYS_CUSTOMCOMPILER-IPDK_IS_AVAILABLE._CONTACT_GF_FAE2021911T4576512/Models/Spectre/models/design_wrapper_mmw.lib.scs[tt_pre]
  Variables: wireopt = 19; C_Z = 0.448p; CGD1 = 0; CGD2 = 0; CL = 1p; gm1 = 4.5m; gm2 = 20m; R_1 = 1k; R_2 = 2.37k; R_Z = 0; ro1 = 50/gm1; ro2 = 103/gm2; C_second_stage = 1.1675e-12*gm2; C_first_stage = 4.2965e-12 * gm2
  Temperature: 27
  Simulator options: additionalArgs=vdsatmod=gds
  Analysis stb: start=1 stop=10G probe=/I13 stbProbeMode=differential
  Analysis ac: start=1 stop=10G
  Output v (/VOP /VON); ac dB20(V) = db((vfreq('ac "/VOP") - vfreq('ac "/VON")))
  Output UGF = unityGainFreq((vfreq('ac "/VOP") - vfreq('ac "/VON")))
  Output BW = bandwidth((vfreq('ac "/VOP") - vfreq('ac "/VON")) 3 "low")
  Output Loop Gain dB20 = db(mag(getData("loopGain" ?result "stb")))
  Output Phase Margin = getData("phaseMargin" ?result "stb_margin")
  Output DC_gain = value(db((vfreq('ac "/VOP") - vfreq('ac "/VON"))) 1)
