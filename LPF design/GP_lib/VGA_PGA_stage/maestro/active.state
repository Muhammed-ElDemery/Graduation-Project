ADE simulation setup
Test GP_lib:VGA_PGA_stage:1: GP_lib/VGA_PGA_stage/config, simulator spectre
  Models: /home/islam/Cadence/PDK_22FDX-EXT_V1.0_3.0_-_DOCUMENTS_----_NOTE_-SYNOPSYS_CUSTOMCOMPILER-IPDK_IS_AVAILABLE._CONTACT_GF_FAE2021911T4576512/Models/Spectre/models/design_wrapper_mmw.lib.scs[tt_pre], /home/islam/Cadence/save.scs
  Variables: DIVIDOR = 0.1; L_RES_DAC = 20n; NF_RES_DAC = 20; W_RES_DAC = 21u; NF_DAC = 20; wireopt = 19; CL = 1p; GM_CM = 400u; LIP_IN = 100n; LN_in2 = 100n; LN_LOAD1 = 100n*2; LP_load2 = 300n; LP_source = 300n; NF_in2 = 20*2; NF_N_LOAD1 = 5*2; NF_P_IN = 20*2*2; NF_P_load2 = 100*2; NF_P_source = 30*2; WP_IN = 37.5u*2*2; WN_LOAD1 = 5.6u*2*2*2; WP_load2 = 309u*2.5*2; WN_in2 = 39.4u*2.5*2; VGS_VBN = 537m; VINCM = 0.86; VOCM = 0.5; WS = 309u/16; NF_S = 20; IBias = 162u/2; CC = 465f; Rz = 14; frq = 100M; LP_CM = 100n; LS_CM = 300n; NF_CM = 10*2; NF_S_CM = 10*4; WP_CM = 5.5u*2; WS_CM = 12.7u*4; VCASCP = 0.424; CC_DAC_0 = 295f; CC_DAC_1 = 339f; CC_DAC_2 = 389f; CC_DAC_3 = 446f; CC_DAC_4 = 509f; CC_DAC_5 = 579f; CC_DAC_6 = 659f; CC_DAC_7 = 748f; CC_DAC_8 = 848f; CC_DAC_9 = 960f; CC_DAC_10 = 1086f; CC_DAC_11 = 1227f; CC_DAC_12 = 1386f; CC_DAC_13 = 1564f; CC_DAC_14 = 1763f; CC_DAC_15 = 1987f; L_DAC = 100n; RZ_DAC = 10; STATE_NOW = 14; W_DAC = 21u; R_one = 1k*DIVIDOR; WP_source = WP_load2*0.286; L_source = LP_source; C_FBK = 0.26526e-9*R_2*0
  Temperature: 27
  Simulator options: additionalArgs=vdsatmod=gds
  Node sets: /I0/net16 = 1; /I0/V1P = 0.5; /I0/V1N = 0.5
  Analysis ac: start=1 stop=10G
  Analysis dc: sweep VGS_VBN start=0.5 stop=0.7 (saves the operating point)
  Analysis stb: start=1 stop=10G probe=/I13 stbProbeMode=differential
  Analysis noise: start=1 stop=10G p=/VOP n=/VON iprobe=/V0
  Output Phase Margin = getData("phaseMargin" ?result "stb_margin")
  Output Loop Gain dB20 = db(mag(getData("loopGain" ?result "stb"))) (unticked)
  Output v (/VOP /VON); ac dB20(V) = db((vfreq('ac "/VOP") - vfreq('ac "/VON"))) (unticked)
  Output DC_gain = value(db((vfreq('ac "/VOP") - vfreq('ac "/VON"))) 1)
  Output BW = bandwidth((vfreq('ac "/VOP") - vfreq('ac "/VON")) 3 "low")
  Output input noise; V**2 / Hz = (getData("in" ?result "noise")**2) (unticked)
  Output integ((getData("in" ?result "noise")**2) 0 600000000 " ")
  Output Noise_density_600M = sqrt((integ((getData("in" ?result "noise")**2) 0 600000000 " ") / 6e+08))
  Output ipnCurves = ipnVRICurves((v("/VOP" ?result "hb_mt_fi") - v("/VON" ?result "hb_mt_fi")) '(2 -1) '(1 0) ?rport 100 ?epoint -50) (unticked)
  Output Input Referred IP3 Point = ipnVRI((v("/VOP" ?result "hb_mt_fi") - v("/VON" ?result "hb_mt_fi")) '(2 -1) '(1 0) ?rport 100 ?epoint -50) (unticked)
  Output 1st Order freq = "cadar(setof(x harmonicFreqList(?result \"hb_mt_fi\") equal(car(x) '(1 0))))" (unticked)
  Output Output Referred IP3 Point = ipnVRI((v("/VOP" ?result "hb_mt_fi") - v("/VON" ?result "hb_mt_fi")) '(2 -1) '(1 0) ?rport 100 ?epoint -50 ?measure "Output")
  Output DC_loop_gain = value(db(mag(getData("loopGain" ?result "stb"))) 1) (unticked)
  Output Noise_density_total = sqrt((integ((getData("in" ?result "noise")**2) 0 2147483647 " ") / 6e+08))
Run mode: Single Run, Sweeps and Corners
Global variables:
  wireopt = 19
Setup values for test GP_lib:VGA_PGA_stage:1: GM_CM = 100m; LN_LOAD1 = 100n; NF_P_IN = 20*2; R_1 = 1k; R_2 = 8.91k,1.58k; WP_IN = 37.5u*2; WN_LOAD1 = 5.6u*2; WP_load2 = 309u*2.5; WN_in2 = 39.4u*2.5; VGS_VBN = 0.5; VINCM = 0.5; VOCM = 0.8; CC = 200f,800f; Rz = 75
