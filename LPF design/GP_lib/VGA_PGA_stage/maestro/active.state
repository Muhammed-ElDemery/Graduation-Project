ADE simulation setup
Test GP_lib:VGA_PGA_stage:1: GP_lib/VGA_PGA_stage/schematic, simulator spectre
  Models: /home/islam/Cadence/PDK_22FDX-EXT_V1.0_3.0_-_DOCUMENTS_----_NOTE_-SYNOPSYS_CUSTOMCOMPILER-IPDK_IS_AVAILABLE._CONTACT_GF_FAE2021911T4576512/Models/Spectre/models/design_wrapper_mmw.lib.scs[tt_pre]
  Variables: wireopt = 19; C_Z = 0.448p; CGD1 = 0; CGD2 = 0; CL = 1p; gm1 = 4.5m; gm2 = 20m; R_1 = 1k; R_2 = 2.37k; R_Z = 0; ro1 = 50/gm1; ro2 = 103/gm2; C_second_stage = 1.1675e-12*gm2; C_first_stage = 4.2965e-12 * gm2
  Temperature: 27
  Simulator options: additionalArgs=vdsatmod=gds
  Analysis stb: start=1 stop=10G probe=/I13 stbProbeMode=differential
  Analysis ac: start=1 stop=10G
  Output v (/VOP /VON); ac dB20(V) = db((vfreq('ac "/VOP") - vfreq('ac "/VON")))
  Output UGF = unityGainFreq((vfreq('ac "/VOP") - vfreq('ac "/VON")))
  Output BW = bandwidth((vfreq('ac "/VOP") - vfreq('ac "/VON")) 3 "low")
  Output Loop Gain dB20 = db(mag(getData("loopGain" ?result "stb")))
  Output Phase Margin = getData("phaseMargin" ?result "stb_margin")
  Output DC_gain = value(db((vfreq('ac "/VOP") - vfreq('ac "/VON"))) 1)
Run mode: Single Run, Sweeps and Corners
Global variables:
  wireopt = 19
Setup values for test GP_lib:VGA_PGA_stage:1: GM_CM = 100m; LIP_IN = 100n; LN_in2 = 100n; LN_LOAD1 = 100n; LP_load2 = 300n; LP_source = 300n; NF_in2 = 20*2; NF_N_LOAD1 = 5*2; NF_P_IN = 20*2; NF_P_load2 = 100*2; NF_P_source = 30*2; R_2 = 8.91k,1.58k; WP_IN = 37.5u*2; WN_LOAD1 = 5.6u*2; WP_load2 = 309u*2.5; WN_in2 = 39.4u*2.5; WP_source = WP_load2*0.286; L_source = LP_source; VGS_VBN = 0.5; VINCM = 0.5; VOCM = 0.8; WS = 309u/16; NF_S = 20; IBias = 162u/2; CC = 200f,800f; Rz = 75; frq = 100M
