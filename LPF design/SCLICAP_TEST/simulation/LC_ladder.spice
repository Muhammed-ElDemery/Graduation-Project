** sch_path: /home/abdo/material/forth_year/Graduation_Project/Filter/SCLICAP_TEST/LC_ladder.sch
**.subckt LC_ladder
L1 net1 IN {L_2} m=1
L2 OUT net1 {L_4} m=1
C1 IN GND {C_1} m=1
C2 net1 GND {C_3} m=1
R1 OUT GND {RL} m=1
R2 IN net2 {RS} m=1
V1 net2 GND {VIN}
C3 OUT GND {C_5} m=1
C4 IN net1 {C_Z1} m=1
C5 net1 OUT {C_Z2} m=1
**.ends
.GLOBAL GND
.end
