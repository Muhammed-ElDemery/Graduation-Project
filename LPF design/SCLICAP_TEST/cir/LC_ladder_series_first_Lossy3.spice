LC_ladder_series_first_Lossy
L1 net4 net8 {L_1}
L2 net3 net4 {L_3}
C2 net4 net6 {C_2}
R1 OUT 0 {RL}
R2 IN net1 {RS}
V1 net1 0 {VIN}
C3 net2 net7 {C_4}
L4 net6 0 {L_2}
L5 net7 0 {L_4}
L6 net10 net2 {L_5}
R3 net8 IN {3*RLOSS}
R4 net2 net3 {2*RLOSS}
R6 net6 net4 {1/(2*RLOSS)}
R7 net7 net2 {1/(2*RLOSS)}
R9 OUT net10 {2*RLOSS}
.end
