ADE simulation setup
Test GP_lib:VGA_input_stage:1: GP_lib/VGA_input_stage/schematic, simulator spectre
  Models: /home/islam/Cadence/PDK_22FDX-EXT_V1.0_3.0_-_DOCUMENTS_----_NOTE_-SYNOPSYS_CUSTOMCOMPILER-IPDK_IS_AVAILABLE._CONTACT_GF_FAE2021911T4576512/Models/Spectre/models/design_wrapper_mmw.lib.scs[tt_pre], /home/islam/Cadence/save.scs
  Variables: frq = 600M; VAMP = 0.1m; VID = 0; VINCM = 800m; LS = 400n; NF_S = 40; LN = 200n; LP = 150n; VBP = 600m; VGS = 478m; wireopt = 19; FACTOR = 3; NF_N = 20*2*FACTOR; NF_P = 10*2*FACTOR; NF_P2 = 10*2*FACTOR; WN = 140u*FACTOR; WP = 16u*FACTOR; WP2 = 24.4u*FACTOR; ISS = 2240u*FACTOR; WS = 320u*2*FACTOR
  Temperature: 27
  Simulator options: additionalArgs=vdsatmod=gds
  Analysis noise: start=1 stop=600M p=/OUTP n=/OUTN iprobe=/V4
  Analysis dc: sweep VBP start=0.3 stop=0.7 (saves the operating point)
  Analysis ac: start=frq stop=10G
  Output VINN_density = sqrt((integ((VNIN("/home/islam/simulation/GP_lib/VGA_input_stage/maestro/results/maestro/ExplorerRun.0/1/GP_lib:VGA_input_stage:1")**2) 0 600000000 " ") / 600000000))
  Output gm_ID_N = (getData("N0:gm" ?result "dc") / getData("N0:id" ?result "dc"))
  Output gm_ID_P = ((- getData("P0:gm" ?result "dc")) / getData("P0:id" ?result "dc"))
  Output GAIN = (getData("N0:gm" ?result "dc") / (getData("P0:gds" ?result "dc") + getData("N0:gds" ?result "dc") + getData("P0:gm" ?result "dc") + getData("P1:gds" ?result "dc")))
  Output Linearity = deriv(deriv((getData("N0:gm" ?result "dc") / (getData("P0:gds" ?result "dc") + getData("N0:gds" ?result "dc") + getData("P0:gm" ?result "dc") + getData("P1:gds" ?result "dc")))))
  Output v (/OUTP /OUTN); ac dB20(V) = db((vfreq('ac "/OUTP") - vfreq('ac "/OUTN")))
  Output ipnCurves = ipnVRICurves((v("/OUTP" ?result "hb_mt_fi") - v("/OUTN" ?result "hb_mt_fi")) '(2 -1) '(1 0) ?rport 100 ?epoint -50)
  Output Output Referred IP3 Point = ipnVRI((v("/OUTP" ?result "hb_mt_fi") - v("/OUTN" ?result "hb_mt_fi")) '(2 -1) '(1 0) ?rport 100 ?epoint -50 ?measure "Output")
  Output 1st Order freq = "cadar(setof(x harmonicFreqList(?result \"hb_mt_fi\") equal(car(x) '(1 0))))" (unticked)
Run mode: Single Run, Sweeps and Corners
Global variables:
  wireopt = 19
Setup values for test GP_lib:VGA_input_stage:1: NF_N = 10*2*FACTOR; WN = 140u*FACTOR/multi; LS = 200n; WS = 320u*2*FACTOR*0.5; multi = 2; RLOAD = 100+RFBK; RS = 20; NF_LOAD = 20; VOCM = 0.5; WN_LOAD = 13u*5/4*2; LP2 = 150n; LN2 = 400n; Rdegen = 0; RFBK = 890; R_feedback = 20k
