ADE simulation setup
Run mode: Single Run, Sweeps and Corners
Tests:
  GP_lib:VGA_input_stage:1: GP_lib/VGA_input_stage/schematic, simulator spectre
    Variables: wireopt = 19; LN = 200n; LP = 150n; NF_N = 10*2*FACTOR; NF_P = 10*2*FACTOR; NF_P2 = 10*2*FACTOR; VBP = 600m; VGS = 478m; WN = 140u*FACTOR/multi; WP = 16u*FACTOR; WP2 = 24.4u*FACTOR; ISS = 2240u*FACTOR; LS = 200n; NF_S = 40; WS = 320u*2*FACTOR*0.5; VINCM = 800m; FACTOR = 3; VID = 0; frq = 600M; VAMP = 0.1m; multi = 2; RLOAD = 100+RFBK; RS = 20; NF_LOAD = 20; VOCM = 0.5; WN_LOAD = 13u*5/4*2; LP2 = 150n; LN2 = 400n; Rdegen = 0; RFBK = 890; R_feedback = 20k
    Outputs: ipnCurves
Global variables:
  wireopt = 19
