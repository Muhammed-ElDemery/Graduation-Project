ADE simulation setup
Run mode: Monte Carlo Sampling
Tests:
  GP_lib:filter_test:1: GP_lib/filter_test/config, simulator spectre
    Variables: wireopt = 19; C_1 = 2*GM*7.829e-10-C_par-2*CD_ADDED; C_2 = 2*GM*11.096e-10-C_par-2*CD_ADDED; C_3 = 2*GM*2.92e-10; C_4 = 2*GM*5.465e-10; C_5 = 2*GM*3.938e-10-C_par-2*CD_ADDED; ISS = 200u*FACTOR; ISS1 = 1m*FACTOR*R; L_1 = 2*GM*4.922e-10-C_par-2*CD_ADDED; L_2 = 2*GM*5.048e-10-C_par-2*CD_ADDED; LN = 200n; LN1 = 60n; LP = 700n; LP1 = 60n; NF_N = 12*4; NF_N1 = 2*FACTOR; NF_P = 16*4; NF_P1 = 2*FACTOR; VBP = 1.076; VOCM = 0.8; WN = 5.1u*FACTOR; WN1 = 8u*FACTOR*R*2; WP = 37.5u*FACTOR; WP1 = 3u*FACTOR*R*2; GM = 1.65*GM2*0.5*FACTOR*2; VINCM = 0.8; AV = 257; AV2 = 100; C_first_stage = 8.6f+2.3f; C_miller = 1.92f; GM2 = 0.7839m; GM_first_stage = 8.976m*R; R_first_stage = 227*1/R; C_par = 30f*FACTOR; C_stab = 0; CGD_1 = 15f*R; CIN = 33f*R; COUT = 16f; ROUT = 108.66k; R = 0.3; FACTOR = 10*F2; VPK = 1m; frq = 200M; LN1_CASC = 20n; WN1_CASC = 5u*FACTOR*R; VCASC = 1.2; C_LPF = 6p; LN2 = 200n*2; LP2 = 100n; LP_CASC = 20n; NF_N2 = 16; NF_P2 = 8; NF_P_CASC = 32; VCASCP = 0.8; WN2 = 45u/8*FACTOR*2; WP2 = 24u/8*FACTOR; WP_CASC = 40u/8*FACTOR*K3; Rdgen = 0; Rdgen_Q = Rdgen/3; CD_ADDED = 0; ISS_input = 1.65m*K*F2; LN_input = 500n*K2; LP_input = 500n; NF_N_input = 100*K; NF_P_input = 30; WN_input = 280u*K*K2*F2; WP_input = 80u*F2; ISS_input2 = ISS_input*2; NF_N_input2 = NF_N_input*2; NF_P_input2 = NF_P_input*2; WN_input2 = WN_input*2; WP_input2 = WP_input*2; Rdegen_input = (K-1)/(K*12.9m*F2); K = 2; K2 = 0.3; K3 = 2.5; F2 = 1; C_comp = 300f; IBias_LNA = 420u; L_RES_DAC = 20n; LNA_NF_P2 = 100; LNA_WP2 = 73.2u; NF_RES_DAC = 60; R_feedback = 1.57k; STATE_LNA = 1; VGS_VBP = 600m; W_RES_DAC = 60u
Global variables:
  wireopt = 19
Specs:
  GP_lib:filter_test:1 / Noise_up_to_200M: < 99.2u
Monte Carlo Sampling options: mcnumpoints=25, yeyistostart=3.0, reliabilitymode=singlestress, mcSigmaTarget=3, sssnumpoints=7000, yeexpectedyield=3, mcmethod=all, wcdinitialpoints=200, yeiterations=10, yeusehistorymc=0, yeuseautomcsamples=1, yecreatecorners=0, haveyeyieldtostart=1, yeusevarreduction=1
