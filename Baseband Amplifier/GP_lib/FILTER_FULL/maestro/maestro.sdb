ADE simulation setup
Run mode: Monte Carlo Sampling
Tests:
  GP_lib:FILTER_FULL:1: GP_lib/FILTER_FULL/schematic, simulator spectre
    Variables: wireopt = 19; C_1 = GM*7.829e-10-C_par; C_2 = GM*11.096e-10-C_par; C_3 = GM*2.92e-10; C_4 = GM*5.465e-10; C_5 = GM*3.938e-10-C_par; L_1 = GM*4.922e-10-C_par; L_2 = GM*5.048e-10-C_par; ISS1 = 3m; LN2 = 400n; LP2 = 100n; LP_CASC = 20n; NF_N2 = 16; NF_P2 = 30; NF_P_CASC = 32; VDD = 1.6; WN2 = 112.5u; WP2 = 30u; WP_CASC = 125u; GM = 29m; C_par = 300f; frq = 200M
    Outputs: sqrt(integ((VNIN("/home/islam/simulation/GP_lib/FILTER_FULL/maestro/results/maestro/ExplorerRun.0/1/GP_lib:FILTER_FULL:1")**2) 0 250000000 " "))
Global variables:
  wireopt = 19
Corners (all switched off):
  model folders: /home/islam/Cadence/PDK_22FDX-EXT_V1.0_3.0_-_DOCUMENTS_----_NOTE_-SYNOPSYS_CUSTOMCOMPILER-IPDK_IS_AVAILABLE._CONTACT_GF_FAE2021911T4576512/Models/Spectre/models
  FF_COLD (off): temperature=-40; VDD=1.68; design_wrapper_mmw.lib.scs[ff_pre]
  SS_HOT (off): temperature=125; VDD=1.52; design_wrapper_mmw.lib.scs[ss_pre]
Monte Carlo Sampling options: mcnumpoints=20, yeyistostart=3.0, reliabilitymode=singlestress, mcSigmaTarget=3, sssnumpoints=7000, yeexpectedyield=3, mcmethod=mismatch, wcdinitialpoints=200, yeiterations=10, yeusehistorymc=0, yeuseautomcsamples=1, yecreatecorners=0, haveyeyieldtostart=1, yeusevarreduction=1
