ADE simulation setup
Test GP_lib:FILTER_FULL:1: GP_lib/FILTER_FULL/schematic, simulator spectre
  Models: /home/islam/Cadence/PDK_22FDX-EXT_V1.0_3.0_-_DOCUMENTS_----_NOTE_-SYNOPSYS_CUSTOMCOMPILER-IPDK_IS_AVAILABLE._CONTACT_GF_FAE2021911T4576512/Models/Spectre/models/design_wrapper_mmw.lib.scs[mc_pre]
  Variables: frq = 200M; wireopt = 19; ISS1 = 3m; LN2 = 400n; LP2 = 100n; LP_CASC = 20n; NF_N2 = 16; NF_P2 = 30; NF_P_CASC = 32; VDD = 1.6; WN2 = 112.5u; WP2 = 30u; WP_CASC = 125u; GM = 29m; C_par = 300f; C_1 = GM*7.829e-10-C_par; C_2 = GM*11.096e-10-C_par; C_3 = GM*2.92e-10; C_4 = GM*5.465e-10; C_5 = GM*3.938e-10-C_par; L_1 = GM*4.922e-10-C_par; L_2 = GM*5.048e-10-C_par
  Temperature: 27
  Simulator options: additionalArgs=vdsatmod=gds
  Analysis hb: fundfreqs=("(frq)" "(frq+10M)") maxharms=("5" "5") tstab=auto errpreset=moderate
  Output v (/VOUTP /VOUTN); ac dB20(V) = db((vfreq('ac "/VOUTP") - vfreq('ac "/VOUTN"))) (unticked)
  Output sqrt(integ((VNIN("/home/islam/simulation/GP_lib/FILTER_FULL/maestro/results/maestro/ExplorerRun.0/1/GP_lib:FILTER_FULL:1")**2) 0 250000000 " ")) (unticked)
  Output Vnoise_RMS_UP_TO_200M = sqrt(integ((VNIN("/home/islam/simulation/GP_lib/FILTER_FULL/maestro/results/maestro/ExplorerRun.0/1/GP_lib:FILTER_FULL:1")**2) 10000 200000000 " ")) (unticked)
  Output ipnCurves = ipnVRICurves((v("/VOUTP" ?result "hb_mt_fi") - v("/VOUTN" ?result "hb_mt_fi")) '(2 -1) '(1 0) ?rport 100 ?epoint -50) (unticked)
  Output Output Referred IP3 Point = ipnVRI((v("/VOUTP" ?result "hb_mt_fi") - v("/VOUTN" ?result "hb_mt_fi")) '(2 -1) '(1 0) ?rport 100 ?epoint -50 ?measure "Output") (unticked)
  Output 1st Order freq = "cadar(setof(x harmonicFreqList(?result \"hb_mt_fi\") equal(car(x) '(1 0))))" (unticked)
  Output BW = bandwidth((vfreq('ac "/VOUTP") - vfreq('ac "/VOUTN")) 0.5 "low") (unticked)
  Output Rejection = value(db((vfreq('ac "/VOUTP") - vfreq('ac "/VOUTN"))) 300000000) (unticked)
  Output "groupDelay((vfreq('ac \"/VOUTP\")-vfreq('ac \"/VOUTN\"))/(vfreq('ac \"/VINP\")-vfreq('ac \"/VINN\")))" = groupDelay(((vfreq('ac "/VOUTP") - vfreq('ac "/VOUTN")) / (vfreq('ac "/VINP") - vfreq('ac "/VINN")))) (unticked)
  Output v (/VINP /VINN); ac mag(V) = (vfreq('ac "/VINP") - vfreq('ac "/VINN")) (unticked)
  Output v (/VO1P /VO1N); ac mag(V) = (vfreq('ac "/VO1P") - vfreq('ac "/VO1N")) (unticked)
  Output v (/VOUTP /VOUTN); ac mag(V) = (vfreq('ac "/VOUTP") - vfreq('ac "/VOUTN")) (unticked)
  Output v (/VOUTP /VOUTN); hb_mt dB20(V) = db((vh('hb "/VOUTP") - vh('hb "/VOUTN"))) (unticked)
  Output Output Referred IP2 Point = ipnVRI((v("/VOUTP" ?result "hb_mt_fi") - v("/VOUTN" ?result "hb_mt_fi")) '(-1 1) '(1 0) ?rport 100 ?ordspur 2 ?epoint -53 ?measure "Output")
Run mode: Monte Carlo Sampling
Global variables:
  wireopt = 19
Corners (all switched off):
  model folders: /home/islam/Cadence/PDK_22FDX-EXT_V1.0_3.0_-_DOCUMENTS_----_NOTE_-SYNOPSYS_CUSTOMCOMPILER-IPDK_IS_AVAILABLE._CONTACT_GF_FAE2021911T4576512/Models/Spectre/models
  FF_COLD (off): temperature=-40; VDD=1.68; design_wrapper_mmw.lib.scs[ff_pre]
  SS_HOT (off): temperature=125; VDD=1.52; design_wrapper_mmw.lib.scs[ss_pre]
Monte Carlo Sampling options: mcnumpoints=20, yeyistostart=3.0, reliabilitymode=singlestress, mcSigmaTarget=3, sssnumpoints=7000, yeexpectedyield=3, mcmethod=mismatch, wcdinitialpoints=200, yeiterations=10, yeusehistorymc=0, yeuseautomcsamples=1, yecreatecorners=0, haveyeyieldtostart=1, yeusevarreduction=1
