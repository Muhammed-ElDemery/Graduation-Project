ADE simulation setup
Test GP_lib:VGA_PGA_stage:1: GP_lib/VGA_PGA_stage/config, simulator spectre
  Models: /home/islam/Cadence/PDK_22FDX-EXT_V1.0_3.0_-_DOCUMENTS_----_NOTE_-SYNOPSYS_CUSTOMCOMPILER-IPDK_IS_AVAILABLE._CONTACT_GF_FAE2021911T4576512/Models/Spectre/models/design_wrapper_mmw.lib.scs[tt_pre], /home/islam/Cadence/save.scs
  Variables: LP_CM = 100n; LS_CM = 300n; NF_CM = 10; NF_S_CM = 10*2; WP_CM = 5.5u; WS_CM = 12.7u*2; wireopt = 19; CL = 1p; GM_CM = 400u; LIP_IN = 100n; LN_in2 = 100n; LN_LOAD1 = 100n*2; LP_load2 = 300n; LP_source = 300n; NF_in2 = 20*2; NF_N_LOAD1 = 5*2; NF_P_IN = 20*2; NF_P_load2 = 100*2; NF_P_source = 30*2; R_1 = 1k*0.1; R_2 = 8.9k*0.1; WP_IN = 37.5u*2*2; WN_LOAD1 = 5.6u*2*2*2; WP_load2 = 309u*2.5*2; WN_in2 = 39.4u*2.5*2; VGS_VBN = 536m; VINCM = 0.5; VOCM = 0.4; WS = 309u/16; NF_S = 20; IBias = 162u/2; Rz = 75; frq = 100M; CC = 0.3p; WP_source = WP_load2*0.286; L_source = LP_source
  Temperature: 27
  Simulator options: additionalArgs=vdsatmod=gds
  Node sets: /I0/net16 = 1; /I0/V1P = 0.5; /I0/V1N = 0.5
  Analysis hb: fundfreqs=("(frq)" "(frq+10M)") maxharms=("5" "5") tstab=auto errpreset=moderate
  Analysis dc: sweep VGS_VBN start=0.5 stop=0.7 (saves the operating point)
  Output Phase Margin = getData("phaseMargin" ?result "stb_margin")
  Output Loop Gain dB20 = db(mag(getData("loopGain" ?result "stb"))) (unticked)
  Output v (/VOP /VON); ac dB20(V) = db((vfreq('ac "/VOP") - vfreq('ac "/VON")))
  Output DC_gain = value(db((vfreq('ac "/VOP") - vfreq('ac "/VON"))) 1)
  Output BW = bandwidth((vfreq('ac "/VOP") - vfreq('ac "/VON")) 3 "low")
  Output input noise; V**2 / Hz = (getData("in" ?result "noise")**2)
  Output integ((getData("in" ?result "noise")**2) 0 600000000 " ")
  Output Noise_density_600M = sqrt((integ((getData("in" ?result "noise")**2) 0 600000000 " ") / 6e+08))
  Output ipnCurves = ipnVRICurves((v("/VOP" ?result "hb_mt_fi") - v("/VON" ?result "hb_mt_fi")) '(2 -1) '(1 0) ?rport 100 ?epoint -50) (unticked)
  Output Input Referred IP3 Point = ipnVRI((v("/VOP" ?result "hb_mt_fi") - v("/VON" ?result "hb_mt_fi")) '(2 -1) '(1 0) ?rport 100 ?epoint -50) (unticked)
  Output 1st Order freq = "cadar(setof(x harmonicFreqList(?result \"hb_mt_fi\") equal(car(x) '(1 0))))" (unticked)
  Output Output Referred IP3 Point = ipnVRI((v("/VOP" ?result "hb_mt_fi") - v("/VON" ?result "hb_mt_fi")) '(2 -1) '(1 0) ?rport 100 ?epoint -50 ?measure "Output")
  Output DC_loop_gain = value(db(mag(getData("loopGain" ?result "stb"))) 1)
  Output Noise_density_total = sqrt((integ((getData("in" ?result "noise")**2) 0 2147483647 " ") / 6e+08))
Run mode: Single Run, Sweeps and Corners
Setup values for test GP_lib:VGA_PGA_stage:1: C_first_stage = 4.2965e-12 * gm2; C_second_stage = 1.1675e-12*gm2; C_Z = 0.2p,0.448p; CGD1 = 0; CGD2 = 0; gm1 = 4.5m; gm2 = 20m; R_1 = 1k; R_2 = 5.3k,2.37k; R_Z = 0; ro1 = 50/gm1; ro2 = 103/gm2
