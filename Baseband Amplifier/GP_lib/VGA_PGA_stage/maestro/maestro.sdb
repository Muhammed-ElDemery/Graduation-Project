ADE simulation setup
Run mode: Single Run, Sweeps and Corners
Tests:
  GP_lib:VGA_PGA_stage:1: GP_lib/VGA_PGA_stage/config, simulator spectre
    Variables: wireopt = 19; CL = 1p; GM_CM = 400u; LIP_IN = 100n; LN_in2 = 100n; LN_LOAD1 = 100n*2; LP_load2 = 300n; LP_source = 300n; NF_in2 = 20*2; NF_N_LOAD1 = 5*2; NF_P_IN = 20*2*2; NF_P_load2 = 100*2; NF_P_source = 30*2; WP_IN = 37.5u*2*2; WN_LOAD1 = 5.6u*2*2*2; WP_load2 = 309u*2.5*2; WN_in2 = 39.4u*2.5*2; WP_source = WP_load2*0.286; L_source = LP_source; VGS_VBN = 534m; VINCM = 0.86; VOCM = 0.5; WS = 309u/16; NF_S = 20; IBias = 162u/2; CC = 465f; Rz = 14; frq = 100M; LP_CM = 100n; LS_CM = 300n; NF_CM = 10*2; NF_S_CM = 10*4; WP_CM = 5.5u*2; WS_CM = 12.7u*4; C_FBK = 0.26526e-9*R_2*0; VCASCP = 0.424; CC_DAC_0 = 295f; CC_DAC_1 = 339f; CC_DAC_2 = 389f; CC_DAC_3 = 446f; CC_DAC_4 = 509f; CC_DAC_5 = 579f; CC_DAC_6 = 659f; CC_DAC_7 = 748f; CC_DAC_8 = 848f; CC_DAC_9 = 960f; CC_DAC_10 = 1086f; CC_DAC_11 = 1227f; CC_DAC_12 = 1386f; CC_DAC_13 = 1564f; CC_DAC_14 = 1763f; CC_DAC_15 = 1987f; L_DAC = 100n; RZ_DAC = 10; STATE_NOW = 1:16; W_DAC = 21u; NF_DAC = 20; DIVIDOR = 0.1; L_RES_DAC = 20n; NF_RES_DAC = 20; W_RES_DAC = 21u; R_one = 1k*DIVIDOR
Global variables:
  wireopt = 19
