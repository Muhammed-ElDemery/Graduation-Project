ADE simulation setup
Run mode: Single Run, Sweeps and Corners
Tests:
  GP_lib:VGA_PGA_stage:1: GP_lib/VGA_PGA_stage/config, simulator spectre
    Variables: wireopt = 19; CL = 1p; GM_CM = 400u; LIP_IN = 100n; LN_in2 = 100n; LN_LOAD1 = 100n*2; LP_load2 = 300n; LP_source = 300n; NF_in2 = 20*2; NF_N_LOAD1 = 5*2; NF_P_IN = 20*2; NF_P_load2 = 100*2; NF_P_source = 30*2; R_1 = 1k*0.1; R_2 = 8.9k*0.1; WP_IN = 37.5u*2*2; WN_LOAD1 = 5.6u*2*2*2; WP_load2 = 309u*2.5*2; WN_in2 = 39.4u*2.5*2; WP_source = WP_load2*0.286; L_source = LP_source; VGS_VBN = 536m; VINCM = 0.5; VOCM = 0.4; WS = 309u/16; NF_S = 20; IBias = 162u/2; CC = 0.3p; Rz = 75; frq = 100M; LP_CM = 100n; LS_CM = 300n; NF_CM = 10; NF_S_CM = 10*2; WP_CM = 5.5u; WS_CM = 12.7u*2
Global variables:
  wireopt = 19
