ADE simulation setup
Run mode: Single Run, Sweeps and Corners
Tests:
  GP_lib:VGA_PGA_stage:1: GP_lib/VGA_PGA_stage/schematic, simulator spectre
    Variables: wireopt = 19; C_first_stage = 4.2965e-12 * gm2; C_second_stage = 1.1675e-12*gm2; C_Z = 0.2p,0.448p; CGD1 = 0; CGD2 = 0; CL = 1p; gm1 = 4.5m; gm2 = 20m; R_1 = 1k; R_2 = 5.3k,2.37k; R_Z = 0; ro1 = 50/gm1; ro2 = 103/gm2
