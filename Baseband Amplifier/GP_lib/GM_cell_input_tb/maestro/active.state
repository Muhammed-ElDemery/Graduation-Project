ADE simulation setup
Test GP_lib:GM_cell_input_tb:1: GP_lib/GM_cell_input_tb/schematic, simulator spectre
  Models: /home/islam/Cadence/PDK_22FDX-EXT_V1.0_3.0_-_DOCUMENTS_----_NOTE_-SYNOPSYS_CUSTOMCOMPILER-IPDK_IS_AVAILABLE._CONTACT_GF_FAE2021911T4576512/Models/Spectre/models/design_wrapper_mmw.lib.scs[tt_pre], /home/islam/Cadence/save.scs
  Variables: frq = 100M; VPK = 10u; wireopt = 19; VGSP = 0.5; VINCM = 0.7; VOCM = 0.7; NF_P_input = 20*5; K = 2; LN_input = 500n; LP_input = 500n; WP_input = 80u; GM = 12.9m; Rdegen_input = 38; ISS_input = 1.65m*2; NF_N_input = 20*5*2; WN_input = 80u*5*0.7*2
  Temperature: 27
  Simulator options: additionalArgs=vdsatmod=gds
  Analysis dc: (saves the operating point)
  Analysis hb: fundfreqs=("(frq)") maxharms=("5") tstab=auto errpreset=moderate
  Analysis noise: start=1 stop=1G p=/VOUTP n=/VOUTN iprobe=/V3
  Output sqrt(integ((VNIN("/home/islam/simulation/GP_lib/GM_cell_input_tb/maestro/results/maestro/ExplorerRun.0/1/GP_lib:GM_cell_input_tb:1")**2) 0 1000000000 " "))
  Output (value(db((vh('hb "/VOUTP") - vh('hb "/VOUTN"))) 100000000) - value(db((vh('hb "/VOUTP") - vh('hb "/VOUTN"))) 300000000))
