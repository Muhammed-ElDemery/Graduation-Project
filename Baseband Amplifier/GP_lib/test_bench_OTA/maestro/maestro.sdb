ADE simulation setup
Run mode: Single Run, Sweeps and Corners
Tests:
  GP_lib:test_bench_OTA:1: GP_lib/test_bench_OTA/schematic, simulator spectre
    Variables: wireopt = 19; L = 100n; NF_LOAD_P = 2; NF_N = 8; VDS = 1.2; VGS = 0.35; W_LOAD_P = 3.5u*1; WN = 16u*1; VCASC = 1; WN_CASC = 4u; L_reg = 30n; WP = 14u*FACTOR; NF_P = 2*FACTOR; W_LOAD_N = 1u*FACTOR; NF_LOAD_N = 1*FACTOR; VB = 0.440; W_SOURCE = 1u*FACTOR; FACTOR = 2
    Outputs: W_ID_N; W_ID_P; Total_C_ID; (getData("N3:gm" ?result "dcOp") / (getData("P2:gm" ?result "dcOp") + getData("P2:gds" ?result "dcOp") + getData("N3:gds" ?result "dcOp"))); (getData("P3:gm" ?result "dcOp") / (getData("N5:gm" ?result "dc") + getData("N5:gds" ?result "dcOp") + getData("P3:gds" ?result "dcOp"))); (getData("P3:gm" ?result "dc") / (getData("N5:gm" ?result "dc") + getData("N5:gds" ?result "dc") + getData("P3:gds" ?result "dc")))
Global variables:
  wireopt = 19
