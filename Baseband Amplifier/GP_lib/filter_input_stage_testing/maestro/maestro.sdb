ADE simulation setup
Run mode: Single Run, Sweeps and Corners
Tests:
  GP_lib:filter_input_stage_testing:1: GP_lib/filter_input_stage_testing/config, simulator spectre
    Variables: wireopt = 19; C_LPF = 6p; C_stab = 0,5p; frq = 100M; ISS1 = 1m*FACTOR*R; LN1 = 60n; LN2 = 200n; LP1 = 60n; LP2 = 100n; LP_CASC = 20n; NF_N1 = 2*FACTOR; NF_N2 = 16; NF_P1 = 2*FACTOR; NF_P2 = 8; NF_P_CASC = 32; Rdgen = 500; Rdgen_Q = Rdgen/3; VBP = 1.076; VCASCP = 0.8; VINCM = 0.7; VOCM = 0.7; VPK = 1m; WN1 = 8u*FACTOR*R*2; WN2 = 45u/8*FACTOR; WP1 = 3u*FACTOR*R*2; WP2 = 24u/8*FACTOR; WP_CASC = 40u/8*FACTOR; FACTOR = 10; R = 0.4; C_1 = 8p; CD_ADDED = 0
Global variables:
  wireopt = 19
