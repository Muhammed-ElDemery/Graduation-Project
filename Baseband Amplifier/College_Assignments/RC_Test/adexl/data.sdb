ADE simulation setup
Run mode: Single Run, Sweeps and Corners
Tests:
  College_Assignments:RC_Test:1: College_Assignments/RC_Test/schematic, simulator spectre
Global variables:
  wireopt = 19
  C = 1p
  R = 1000
