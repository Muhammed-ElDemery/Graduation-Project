ADE simulation setup
Test GP:LNA_first_stage:1: GP/LNA_first_stage/schematic, simulator spectre
  Models: /home/islam/Cadence/PDK_22FDX-EXT_V1.0_3.0_-_DOCUMENTS_----_NOTE_-SYNOPSYS_CUSTOMCOMPILER-IPDK_IS_AVAILABLE._CONTACT_GF_FAE2021911T4576512/Models/Spectre/models/design_wrapper_mmw.lib.scs[tt_pre]
  Variables: Lin = 900p; Q = 15; J = 350; C1 = 1f; Cc = 45f; IBias = "VAR(\"J\")*VAR(\"WF\")*VAR(\"NF\")*VAR(\"Mul\")"; LG = 600p; LS = 200p; Mul = 4; Mul_casc = 4; NF = 96; NF_casc = 96; VNF = 3; VNF_casc = 3; WF = 0.5u; WF_casc = 0.5u
  Temperature: 27
  Simulator options: additionalArgs=vdsatmod=gds
  Analysis dc: (saves the operating point)
  Analysis sp: start=0.2G stop=8G step=0.1G oprobe=/PORT1 iprobe=/PORT0 ports=("/PORT0" "/PORT1") donoise=yes
  Output Gmax dB10 = db10(gmax(sp(1 1 ?result "sp") sp(1 2 ?result "sp") sp(2 1 ?result "sp") sp(2 2 ?result "sp")))
  Output S21 dB20 = db(spm('sp 2 1))
  Output NF dB10 = db10(getData("F" ?result "sp_noise"))
  Output NFmin dB10 = db10(getData("Fmin" ?result "sp_noise"))
  Output S11 dB20 = db(spm('sp 1 1))
  Output S22 = spm('sp 2 2)
Run mode: Single Run, Sweeps and Corners
Global variables:
  wireopt = 19
Setup values for test GP:LNA_first_stage:1: IBias = VAR("J")*VAR("WF")*VAR("NF")*VAR("Mul")
