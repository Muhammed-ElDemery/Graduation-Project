ADE simulation setup
Run mode: Single Run, Sweeps and Corners
Tests:
  GP:LNA_first_stage:1: GP/LNA_first_stage/schematic, simulator spectre
    Variables: WF = 0.5u; NF = 96; Mul = 4; VNF = 3; WF_casc = 0.5u; NF_casc = 96; Mul_casc = 4; VNF_casc = 3; C1 = 1f; Cc = 45f; LG = 600p; LS = 200p; IBias = VAR("J")*VAR("WF")*VAR("NF")*VAR("Mul"); J = 350; Q = 15; Lin = 900p
Global variables:
  wireopt = 19
