ADE simulation setup
Test GP:SLVT:1: GP/SLVT/schematic, simulator spectre
  Models: /home/islam/Cadence/PDK_22FDX-EXT_V1.0_3.0_-_DOCUMENTS_----_NOTE_-SYNOPSYS_CUSTOMCOMPILER-IPDK_IS_AVAILABLE._CONTACT_GF_FAE2021911T4576512/Models/Spectre/models/design_wrapper_mmw.lib.scs[tt_pre]
  Variables: wireopt = 19
  Temperature: 27
  Simulator options: additionalArgs=vdsatmod=gds
Run mode: Single Run, Sweeps and Corners
Global variables:
  wireopt = 19
