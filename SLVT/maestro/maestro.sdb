ADE simulation setup
Run mode: Single Run, Sweeps and Corners
Tests:
  GP:SLVT:1: GP/SLVT/schematic, simulator spectre
    Variables: wireopt = 19
Global variables:
  wireopt = 19
