ADE simulation setup
Run mode: Single Run, Sweeps and Corners
Tests:
  Hazem_Lib:Mixer_Learn_Simulation:1: Hazem_Lib/Mixer_Learn_Simulation/schematic, simulator spectre
    Variables: wireopt = 19; lo_freq = rf_freq-200M; NF1 = 16; rf_freq = 4.4G; rf_Pin = -10; WF1 = 800n; Mul1 = 1; Vb = 0.8
    Outputs: Input Referred IP3 Point; Input Referred 1dB Compression Point; Input Referred IP2 Point
Global variables:
  wireopt = 19 (off)
  MOS = "tt_pre"
  WF1 = 700n:100n:900n (off)
  Mul1 = 1 (off)
  NF1 = 16:8:32 (off)
  Vb = 0.8 (off)
Corners:
  fast (off): temperature=-40; MOS="ff_pre"
  slow (off): temperature=85; MOS="ss_pre"
Specs:
  Hazem_Lib:Mixer_Learn_Simulation:1 / Input Referred IP3 Point: > 15
  Hazem_Lib:Mixer_Learn_Simulation:1 / Input Referred IP2 Point: > 50
  Hazem_Lib:Mixer_Learn_Simulation:1 / Input Referred 1dB Compression Point: > 5
