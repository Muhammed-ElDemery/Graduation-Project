ADE simulation setup
Test Hazem_Lib:Mixer_Learn_Simulation:1: Hazem_Lib/Mixer_Learn_Simulation/schematic, simulator spectre
  Models: /home/islam/Cadence/PDK_22FDX-EXT_V1.0_3.0_-_DOCUMENTS_----_NOTE_-SYNOPSYS_CUSTOMCOMPILER-IPDK_IS_AVAILABLE._CONTACT_GF_FAE2021911T4576512/Models/Spectre/models/design_wrapper_mmw.lib.scs[tt_pre]
  Variables: lo_freq = 30G; NF1 = 24; rf_freq = 32G; rf_Pin = -10; WF1 = 1u; wireopt = 19
  Temperature: 27
  Simulator options: additionalArgs=vdsatmod=gds
  Analysis hb: fundfreqs=("(lo_freq)") maxharms=("11") tstab=0 errpreset=conservative
  Analysis hbsp: start=-3G stop=3G step=0.5G ports=[/PORT2 /PORT1] maxsideband=11 donoise=yes
