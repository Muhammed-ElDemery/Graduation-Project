ADE simulation setup
Test Hazem_Lib:Mixer_Learn_Simulation:1: Hazem_Lib/Mixer_Learn_Simulation/schematic, simulator spectre
  Models: /home/islam/Cadence/PDK_22FDX-EXT_V1.0_3.0_-_DOCUMENTS_----_NOTE_-SYNOPSYS_CUSTOMCOMPILER-IPDK_IS_AVAILABLE._CONTACT_GF_FAE2021911T4576512/Models/Spectre/models/design_wrapper_mmw.lib.scs[VAR(\]
  Variables: Vb = 0.8; Mul1 = 1; NF1 = 16; rf_Pin = -10; WF1 = 800n; wireopt = 19; rf_freq = 4.4G; lo_freq = rf_freq-200M
  Temperature: 27
  Simulator options: additionalArgs=vdsatmod=gds
  Files: DSPF \  
  Analysis hb: fundfreqs=("(lo_freq)") maxharms=("11") tstab=0 errpreset=conservative
  Analysis hbsp: start=-3.8G stop=3.8G step=0.2G ports=[/PORT2 /PORT1 /PORT0] maxsideband=11 donoise=yes
  Output NFSSB = getData("NFieee" ?result "hbsp") (unticked)
  Output NFdsb = getData("NFdsb" ?result "hbsp") (unticked)
  Output S11 dB20 = db(spm('hbsp 1 1)) (unticked)
  Output S22 dB20 = db(spm('hbsp 2 2)) (unticked)
  Output S21 dB20 = db(spm('hbsp 2 1)) (unticked)
  Output S12 dB20 = db(spm('hbsp 1 2)) (unticked)
  Output Input Referred IP3 Point = ipnVRI((v("/IF" ?result "hb_mt_fi") - 0.0) '(-1 2 -1) '(-1 1 0) ?rport resultParam("PORT1:r" ?result "hb_mt_fi") ?epoint -10 ?measure "Input") (unticked)
  Output Input Referred IP2 Point = ipnVRI(v("/IF" ?result "hb_mt_fi") '(-1 1 1) '(-1 1 0) ?iport i("/PORT1/PLUS" ?result "hb_mt_fi") ?ordspur 2 ?epoint -10 ?measure "Input") (unticked)
  Output Input Referred 1dB Compression Point = compressionVRI((v("/IF" ?result "hb_mt_fi") - 0.0) '(-1 1) ?rport resultParam("PORT1:r" ?result "hb_mt_fi") ?epoint -10 ?gcomp 1 ?measure "Input") (unticked)
  Output S23 dB20 = db(spm('hbsp 2 3)) (unticked)
  Output S31 dB20 = db(spm('hbsp 3 1)) (unticked)
  Output S32 dB20 = db(spm('hbsp 3 2)) (unticked)
  Output S13 dB20 = db(spm('hbsp 1 3)) (unticked)
  Output S33 dB20 = db(spm('hbsp 3 3)) (unticked)
  Output Z33 reOhm = real(zpm('hbsp 3 3))
  Output Z33 imOhm = imag(zpm('hbsp 3 3))
  Output Z33 reOhm, 4G = real(drplRFValueAt(zpm('hbsp 3 3) "4G"))
  Output Z33 imOhm, 4G = imag(drplRFValueAt(zpm('hbsp 3 3) "4G"))
Run mode: Single Run, Sweeps and Corners
Global variables:
  wireopt = 19 (off)
  MOS = "tt_pre"
  WF1 = 700n:100n:900n (off)
  Mul1 = 1 (off)
  NF1 = 16:8:32 (off)
  Vb = 0.8 (off)
Corners:
  fast (off): temperature=-40; MOS="ff_pre"
  slow (off): temperature=85; MOS="ss_pre"
Specs:
  Hazem_Lib:Mixer_Learn_Simulation:1 / Input Referred IP3 Point: > 15
  Hazem_Lib:Mixer_Learn_Simulation:1 / Input Referred IP2 Point: > 50
  Hazem_Lib:Mixer_Learn_Simulation:1 / Input Referred 1dB Compression Point: > 5
