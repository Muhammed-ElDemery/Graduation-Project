ADE simulation setup
Test GP:charecterize_devices:1: GP/charecterize_devices/schematic, simulator spectre
  Models: /home/islam/Cadence/PDK_22FDX-EXT_V1.0_3.0_-_DOCUMENTS_----_NOTE_-SYNOPSYS_CUSTOMCOMPILER-IPDK_IS_AVAILABLE._CONTACT_GF_FAE2021911T4576512/Models/Spectre/models/design_wrapper_mmw.lib.scs[tt_pre], /home/islam/Cadence/save.scs
  Variables: VFingers = 1; IBIAS = 1m; Mul = 1; NF = 90; VBack = -1.5; VDS = 0.8; WF = 0.5u
  Temperature: 27
  Simulator options: additionalArgs=vdsatmod=gds
  Analysis dc: (saves the operating point)
  Analysis sp: start=400M stop=400G step=0.5G oprobe=/PORT1 iprobe=/PORT0 donoise=yes
  Output NFmin dB10 = db10(getData("Fmin" ?result "sp_noise")) (unticked)
  Output Gmax dB10 = db10(gmax(sp(1 1 ?result "sp") sp(1 2 ?result "sp") sp(2 1 ?result "sp") sp(2 2 ?result "sp"))) (unticked)
  Output H21 dB20 = db(hp(2 1 ?result "sp")) (unticked)
  Output NFmin@8G = value(db10(getData("Fmin" ?result "sp_noise")) 8e+09 ?period nil ?xName "time")
  Output FT = cross(db(hp(2 1 ?result "sp")) "0" 1 "either" nil nil nil)
  Output FMAX = cross(db10(gmax(sp(1 1 ?result "sp") sp(1 2 ?result "sp") sp(2 1 ?result "sp") sp(2 2 ?result "sp"))) "0" 1 "either" nil nil nil)
  Output JD = (VAR("IBIAS") / (VAR("NF") * VAR("WF")))
Run mode: Single Run, Sweeps and Corners
Setup values for test GP:charecterize_devices:1: IBIAS = 1m:0.5m:12m
