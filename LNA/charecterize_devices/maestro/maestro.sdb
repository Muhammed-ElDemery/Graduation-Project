ADE simulation setup
Run mode: Single Run, Sweeps and Corners
Tests:
  GP:charecterize_devices:1: GP/charecterize_devices/schematic, simulator spectre
    Variables: Mul = 1; NF = 90; VBack = -1.5; VDS = 0.8; WF = 0.5u; IBIAS = 1m:0.5m:12m; VFingers = 1
    Outputs: JD
