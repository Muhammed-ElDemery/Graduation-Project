ADE simulation setup
Run mode: Single Run, Sweeps and Corners
Tests:
  GP:Balun:1: GP/Balun/schematic, simulator spectre
    Variables: Cout = 0; Re = 50; Cin = 0
Global variables:
  wireopt = 19
