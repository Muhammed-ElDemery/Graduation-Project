ADE simulation setup
Test GP:Balun:1: GP/Balun/schematic, simulator spectre
  Models: /home/islam/Cadence/PDK_22FDX-EXT_V1.0_3.0_-_DOCUMENTS_----_NOTE_-SYNOPSYS_CUSTOMCOMPILER-IPDK_IS_AVAILABLE._CONTACT_GF_FAE2021911T4576512/Models/Spectre/models/design_wrapper_mmw.lib.scs[tt_pre]
  Variables: Rser = 5; Cin = 500f; Cout = 500f
  Temperature: 27
  Simulator options: additionalArgs=vdsatmod=gds
  Analysis sp: start=0.4G stop=10G step=0.1G
  Output S11 = spm('sp 1 1)
  Output S22 = spm('sp 2 2)
  Output S11 dB20 = db(spm('sp 1 1))
  Output S22 dB20 = db(spm('sp 2 2))
